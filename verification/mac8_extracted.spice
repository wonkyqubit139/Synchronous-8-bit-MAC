* NGSPICE file created from mac8.ext - technology: sky130A

.subckt sky130_ef_sc_hd__decap_12 VGND VPWR VPB VNB
X0 VPWR VGND VPWR VPB sky130_fd_pr__pfet_01v8_hvt ad=0.2262 pd=2.26 as=0 ps=0 w=0.87 l=4.73
X1 VGND VPWR VGND VNB sky130_fd_pr__nfet_01v8 ad=0.143 pd=1.62 as=0 ps=0 w=0.55 l=4.73
.ends

.subckt sky130_fd_sc_hd__decap_3 VPWR VGND VPB VNB
X0 VPWR VGND VPWR VPB sky130_fd_pr__pfet_01v8_hvt ad=0.2262 pd=2.26 as=0 ps=0 w=0.87 l=0.59
X1 VGND VPWR VGND VNB sky130_fd_pr__nfet_01v8 ad=0.143 pd=1.62 as=0 ps=0 w=0.55 l=0.59
.ends

.subckt sky130_fd_sc_hd__nand2_1 VPB VNB VGND VPWR A Y B
X0 VPWR A Y VPB sky130_fd_pr__pfet_01v8_hvt ad=0.26 pd=2.52 as=0.135 ps=1.27 w=1 l=0.15
X1 Y A a_113_47# VNB sky130_fd_pr__nfet_01v8 ad=0.169 pd=1.82 as=0.08775 ps=0.92 w=0.65 l=0.15
X2 a_113_47# B VGND VNB sky130_fd_pr__nfet_01v8 ad=0.08775 pd=0.92 as=0.169 ps=1.82 w=0.65 l=0.15
X3 Y B VPWR VPB sky130_fd_pr__pfet_01v8_hvt ad=0.135 pd=1.27 as=0.26 ps=2.52 w=1 l=0.15
.ends

.subckt sky130_fd_sc_hd__clkbuf_4 VGND VPWR A X VPB VNB
X0 VPWR A a_27_47# VPB sky130_fd_pr__pfet_01v8_hvt ad=0.165 pd=1.33 as=0.265 ps=2.53 w=1 l=0.15
X1 VGND a_27_47# X VNB sky130_fd_pr__nfet_01v8 ad=0.1218 pd=1.42 as=0.0588 ps=0.7 w=0.42 l=0.15
X2 VGND a_27_47# X VNB sky130_fd_pr__nfet_01v8 ad=0.0588 pd=0.7 as=0.0588 ps=0.7 w=0.42 l=0.15
X3 X a_27_47# VPWR VPB sky130_fd_pr__pfet_01v8_hvt ad=0.14 pd=1.28 as=0.14 ps=1.28 w=1 l=0.15
X4 X a_27_47# VGND VNB sky130_fd_pr__nfet_01v8 ad=0.0588 pd=0.7 as=0.0588 ps=0.7 w=0.42 l=0.15
X5 VGND A a_27_47# VNB sky130_fd_pr__nfet_01v8 ad=0.07035 pd=0.755 as=0.1113 ps=1.37 w=0.42 l=0.15
X6 VPWR a_27_47# X VPB sky130_fd_pr__pfet_01v8_hvt ad=0.3 pd=2.6 as=0.14 ps=1.28 w=1 l=0.15
X7 X a_27_47# VGND VNB sky130_fd_pr__nfet_01v8 ad=0.0588 pd=0.7 as=0.07035 ps=0.755 w=0.42 l=0.15
X8 X a_27_47# VPWR VPB sky130_fd_pr__pfet_01v8_hvt ad=0.14 pd=1.28 as=0.165 ps=1.33 w=1 l=0.15
X9 VPWR a_27_47# X VPB sky130_fd_pr__pfet_01v8_hvt ad=0.14 pd=1.28 as=0.14 ps=1.28 w=1 l=0.15
.ends

.subckt sky130_fd_sc_hd__a22o_1 VPWR VGND VPB VNB B1 A1 A2 X B2
X0 VPWR A2 a_109_297# VPB sky130_fd_pr__pfet_01v8_hvt ad=0.155 pd=1.31 as=0.16 ps=1.32 w=1 l=0.15
X1 a_27_297# B1 a_109_47# VNB sky130_fd_pr__nfet_01v8 ad=0.169 pd=1.82 as=0.07475 ps=0.88 w=0.65 l=0.15
X2 VGND A2 a_373_47# VNB sky130_fd_pr__nfet_01v8 ad=0.10075 pd=0.96 as=0.11375 ps=1 w=0.65 l=0.15
X3 X a_27_297# VPWR VPB sky130_fd_pr__pfet_01v8_hvt ad=0.26 pd=2.52 as=0.155 ps=1.31 w=1 l=0.15
X4 a_27_297# B1 a_109_297# VPB sky130_fd_pr__pfet_01v8_hvt ad=0.25285 pd=2.52 as=0.135 ps=1.27 w=1 l=0.15
X5 a_109_297# A1 VPWR VPB sky130_fd_pr__pfet_01v8_hvt ad=0.16 pd=1.32 as=0.2529 ps=2.52 w=1 l=0.15
X6 a_373_47# A1 a_27_297# VNB sky130_fd_pr__nfet_01v8 ad=0.11375 pd=1 as=0.169 ps=1.82 w=0.65 l=0.15
X7 X a_27_297# VGND VNB sky130_fd_pr__nfet_01v8 ad=0.169 pd=1.82 as=0.10075 ps=0.96 w=0.65 l=0.15
X8 a_109_297# B2 a_27_297# VPB sky130_fd_pr__pfet_01v8_hvt ad=0.135 pd=1.27 as=0.26 ps=2.52 w=1 l=0.15
X9 a_109_47# B2 VGND VNB sky130_fd_pr__nfet_01v8 ad=0.07475 pd=0.88 as=0.169 ps=1.82 w=0.65 l=0.15
.ends

.subckt sky130_fd_sc_hd__xnor2_1 VGND VPWR B Y A VPB VNB
X0 a_377_297# A VPWR VPB sky130_fd_pr__pfet_01v8_hvt ad=0.105 pd=1.21 as=0.365 ps=1.73 w=1 l=0.15
X1 a_47_47# B VPWR VPB sky130_fd_pr__pfet_01v8_hvt ad=0.135 pd=1.27 as=0.3 ps=2.6 w=1 l=0.15
X2 a_129_47# B a_47_47# VNB sky130_fd_pr__nfet_01v8 ad=0.06825 pd=0.86 as=0.169 ps=1.82 w=0.65 l=0.15
X3 a_285_47# B VGND VNB sky130_fd_pr__nfet_01v8 ad=0.08775 pd=0.92 as=0.169 ps=1.82 w=0.65 l=0.15
X4 Y a_47_47# a_285_47# VNB sky130_fd_pr__nfet_01v8 ad=0.195 pd=1.9 as=0.08775 ps=0.92 w=0.65 l=0.15
X5 VGND A a_129_47# VNB sky130_fd_pr__nfet_01v8 ad=0.08775 pd=0.92 as=0.06825 ps=0.86 w=0.65 l=0.15
X6 VPWR A a_47_47# VPB sky130_fd_pr__pfet_01v8_hvt ad=0.365 pd=1.73 as=0.135 ps=1.27 w=1 l=0.15
X7 VPWR a_47_47# Y VPB sky130_fd_pr__pfet_01v8_hvt ad=0.36 pd=2.72 as=0.165 ps=1.33 w=1 l=0.15
X8 Y B a_377_297# VPB sky130_fd_pr__pfet_01v8_hvt ad=0.165 pd=1.33 as=0.105 ps=1.21 w=1 l=0.15
X9 a_285_47# A VGND VNB sky130_fd_pr__nfet_01v8 ad=0.169 pd=1.82 as=0.08775 ps=0.92 w=0.65 l=0.15
.ends

.subckt sky130_fd_sc_hd__or2b_1 VGND VPWR VNB VPB A X B_N
X0 a_219_297# a_27_53# VGND VNB sky130_fd_pr__nfet_01v8 ad=0.0567 pd=0.69 as=0.1575 ps=1.17 w=0.42 l=0.15
X1 VGND B_N a_27_53# VNB sky130_fd_pr__nfet_01v8 ad=0.1575 pd=1.17 as=0.1092 ps=1.36 w=0.42 l=0.15
X2 VPWR A a_301_297# VPB sky130_fd_pr__pfet_01v8_hvt ad=0.14825 pd=1.34 as=0.0441 ps=0.63 w=0.42 l=0.15
X3 X a_219_297# VGND VNB sky130_fd_pr__nfet_01v8 ad=0.1755 pd=1.84 as=0.10187 ps=0.99 w=0.65 l=0.15
X4 a_301_297# a_27_53# a_219_297# VPB sky130_fd_pr__pfet_01v8_hvt ad=0.0441 pd=0.63 as=0.1092 ps=1.36 w=0.42 l=0.15
X5 X a_219_297# VPWR VPB sky130_fd_pr__pfet_01v8_hvt ad=0.27 pd=2.54 as=0.14825 ps=1.34 w=1 l=0.15
X6 a_27_53# B_N VPWR VPB sky130_fd_pr__pfet_01v8_hvt ad=0.1176 pd=1.4 as=0.1092 ps=1.36 w=0.42 l=0.15
X7 VGND A a_219_297# VNB sky130_fd_pr__nfet_01v8 ad=0.10187 pd=0.99 as=0.0567 ps=0.69 w=0.42 l=0.15
.ends

.subckt sky130_fd_sc_hd__decap_6 VPWR VGND VPB VNB
X0 VPWR VGND VPWR VPB sky130_fd_pr__pfet_01v8_hvt ad=0.2262 pd=2.26 as=0 ps=0 w=0.87 l=1.97
X1 VGND VPWR VGND VNB sky130_fd_pr__nfet_01v8 ad=0.143 pd=1.62 as=0 ps=0 w=0.55 l=1.97
.ends

.subckt sky130_fd_sc_hd__decap_8 VPWR VGND VPB VNB
X0 VPWR VGND VPWR VPB sky130_fd_pr__pfet_01v8_hvt ad=0.2262 pd=2.26 as=0 ps=0 w=0.87 l=2.89
X1 VGND VPWR VGND VNB sky130_fd_pr__nfet_01v8 ad=0.143 pd=1.62 as=0 ps=0 w=0.55 l=2.89
.ends

.subckt sky130_fd_sc_hd__dfxtp_1 Q CLK D VPB VNB VPWR VGND
X0 Q a_1059_315# VGND VNB sky130_fd_pr__nfet_01v8 ad=0.169 pd=1.82 as=0.08775 ps=0.92 w=0.65 l=0.15
X1 a_891_413# a_193_47# a_634_159# VNB sky130_fd_pr__nfet_01v8 ad=0.0684 pd=0.74 as=0.0989 ps=0.995 w=0.36 l=0.15
X2 a_561_413# a_27_47# a_466_413# VPB sky130_fd_pr__pfet_01v8_hvt ad=0.07665 pd=0.785 as=0.06825 ps=0.745 w=0.42 l=0.15
X3 VPWR CLK a_27_47# VPB sky130_fd_pr__pfet_01v8_hvt ad=0.0864 pd=0.91 as=0.1664 ps=1.8 w=0.64 l=0.15
X4 Q a_1059_315# VPWR VPB sky130_fd_pr__pfet_01v8_hvt ad=0.26 pd=2.52 as=0.135 ps=1.27 w=1 l=0.15
X5 a_381_47# D VPWR VPB sky130_fd_pr__pfet_01v8_hvt ad=0.05775 pd=0.695 as=0.1092 ps=1.36 w=0.42 l=0.15
X6 VGND a_634_159# a_592_47# VNB sky130_fd_pr__nfet_01v8 ad=0.12095 pd=1.085 as=0.0696 ps=0.765 w=0.42 l=0.15
X7 VPWR a_891_413# a_1059_315# VPB sky130_fd_pr__pfet_01v8_hvt ad=0.135 pd=1.27 as=0.27 ps=2.54 w=1 l=0.15
X8 a_466_413# a_193_47# a_381_47# VPB sky130_fd_pr__pfet_01v8_hvt ad=0.06825 pd=0.745 as=0.05775 ps=0.695 w=0.42 l=0.15
X9 VPWR a_634_159# a_561_413# VPB sky130_fd_pr__pfet_01v8_hvt ad=0.17887 pd=1.26 as=0.07665 ps=0.785 w=0.42 l=0.15
X10 a_634_159# a_466_413# VGND VNB sky130_fd_pr__nfet_01v8 ad=0.0989 pd=0.995 as=0.12095 ps=1.085 w=0.64 l=0.15
X11 a_634_159# a_466_413# VPWR VPB sky130_fd_pr__pfet_01v8_hvt ad=0.1095 pd=1.075 as=0.17887 ps=1.26 w=0.75 l=0.15
X12 a_975_413# a_193_47# a_891_413# VPB sky130_fd_pr__pfet_01v8_hvt ad=0.0882 pd=0.84 as=0.0567 ps=0.69 w=0.42 l=0.15
X13 VGND a_1059_315# a_1017_47# VNB sky130_fd_pr__nfet_01v8 ad=0.1092 pd=1.36 as=0.066 ps=0.745 w=0.42 l=0.15
X14 a_193_47# a_27_47# VGND VNB sky130_fd_pr__nfet_01v8 ad=0.1092 pd=1.36 as=0.0567 ps=0.69 w=0.42 l=0.15
X15 a_891_413# a_27_47# a_634_159# VPB sky130_fd_pr__pfet_01v8_hvt ad=0.0567 pd=0.69 as=0.1095 ps=1.075 w=0.42 l=0.15
X16 a_592_47# a_193_47# a_466_413# VNB sky130_fd_pr__nfet_01v8 ad=0.0696 pd=0.765 as=0.0621 ps=0.705 w=0.36 l=0.15
X17 a_1017_47# a_27_47# a_891_413# VNB sky130_fd_pr__nfet_01v8 ad=0.066 pd=0.745 as=0.0684 ps=0.74 w=0.36 l=0.15
X18 VPWR a_1059_315# a_975_413# VPB sky130_fd_pr__pfet_01v8_hvt ad=0.1113 pd=1.37 as=0.0882 ps=0.84 w=0.42 l=0.15
X19 a_466_413# a_27_47# a_381_47# VNB sky130_fd_pr__nfet_01v8 ad=0.0621 pd=0.705 as=0.0813 ps=0.83 w=0.36 l=0.15
X20 a_193_47# a_27_47# VPWR VPB sky130_fd_pr__pfet_01v8_hvt ad=0.1664 pd=1.8 as=0.0864 ps=0.91 w=0.64 l=0.15
X21 VGND a_891_413# a_1059_315# VNB sky130_fd_pr__nfet_01v8 ad=0.08775 pd=0.92 as=0.169 ps=1.82 w=0.65 l=0.15
X22 a_381_47# D VGND VNB sky130_fd_pr__nfet_01v8 ad=0.0813 pd=0.83 as=0.1092 ps=1.36 w=0.42 l=0.15
X23 VGND CLK a_27_47# VNB sky130_fd_pr__nfet_01v8 ad=0.0567 pd=0.69 as=0.1092 ps=1.36 w=0.42 l=0.15
.ends

.subckt sky130_fd_sc_hd__a21o_1 VPWR VGND VPB VNB A2 A1 B1 X
X0 a_81_21# B1 VGND VNB sky130_fd_pr__nfet_01v8 ad=0.08937 pd=0.925 as=0.25675 ps=1.44 w=0.65 l=0.15
X1 a_299_297# B1 a_81_21# VPB sky130_fd_pr__pfet_01v8_hvt ad=0.1375 pd=1.275 as=0.26 ps=2.52 w=1 l=0.15
X2 VPWR a_81_21# X VPB sky130_fd_pr__pfet_01v8_hvt ad=0.26 pd=2.52 as=0.26 ps=2.52 w=1 l=0.15
X3 VPWR A1 a_299_297# VPB sky130_fd_pr__pfet_01v8_hvt ad=0.14 pd=1.28 as=0.1375 ps=1.275 w=1 l=0.15
X4 VGND a_81_21# X VNB sky130_fd_pr__nfet_01v8 ad=0.25675 pd=1.44 as=0.169 ps=1.82 w=0.65 l=0.15
X5 VGND A2 a_384_47# VNB sky130_fd_pr__nfet_01v8 ad=0.17225 pd=1.83 as=0.091 ps=0.93 w=0.65 l=0.15
X6 a_299_297# A2 VPWR VPB sky130_fd_pr__pfet_01v8_hvt ad=0.265 pd=2.53 as=0.14 ps=1.28 w=1 l=0.15
X7 a_384_47# A1 a_81_21# VNB sky130_fd_pr__nfet_01v8 ad=0.091 pd=0.93 as=0.08937 ps=0.925 w=0.65 l=0.15
.ends

.subckt sky130_fd_sc_hd__and2_1 VPWR VGND X B A VPB VNB
X0 VPWR B a_59_75# VPB sky130_fd_pr__pfet_01v8_hvt ad=0.16655 pd=1.39 as=0.0567 ps=0.69 w=0.42 l=0.15
X1 X a_59_75# VPWR VPB sky130_fd_pr__pfet_01v8_hvt ad=0.475 pd=2.95 as=0.16655 ps=1.39 w=1 l=0.15
X2 VGND B a_145_75# VNB sky130_fd_pr__nfet_01v8 ad=0.1118 pd=1.04 as=0.0567 ps=0.69 w=0.42 l=0.15
X3 a_59_75# A VPWR VPB sky130_fd_pr__pfet_01v8_hvt ad=0.0567 pd=0.69 as=0.1176 ps=1.4 w=0.42 l=0.15
X4 X a_59_75# VGND VNB sky130_fd_pr__nfet_01v8 ad=0.182 pd=1.86 as=0.1118 ps=1.04 w=0.65 l=0.15
X5 a_145_75# A a_59_75# VNB sky130_fd_pr__nfet_01v8 ad=0.0567 pd=0.69 as=0.1176 ps=1.4 w=0.42 l=0.15
.ends

.subckt sky130_fd_sc_hd__and3_1 VGND VPWR X B A C VPB VNB
X0 VPWR A a_27_47# VPB sky130_fd_pr__pfet_01v8_hvt ad=0.0567 pd=0.69 as=0.1092 ps=1.36 w=0.42 l=0.15
X1 VPWR C a_27_47# VPB sky130_fd_pr__pfet_01v8_hvt ad=0.14222 pd=1.335 as=0.06615 ps=0.735 w=0.42 l=0.15
X2 a_181_47# B a_109_47# VNB sky130_fd_pr__nfet_01v8 ad=0.0441 pd=0.63 as=0.0441 ps=0.63 w=0.42 l=0.15
X3 VGND C a_181_47# VNB sky130_fd_pr__nfet_01v8 ad=0.13165 pd=1.14 as=0.0441 ps=0.63 w=0.42 l=0.15
X4 a_27_47# B VPWR VPB sky130_fd_pr__pfet_01v8_hvt ad=0.06615 pd=0.735 as=0.0567 ps=0.69 w=0.42 l=0.15
X5 X a_27_47# VPWR VPB sky130_fd_pr__pfet_01v8_hvt ad=0.26 pd=2.52 as=0.14222 ps=1.335 w=1 l=0.15
X6 X a_27_47# VGND VNB sky130_fd_pr__nfet_01v8 ad=0.169 pd=1.82 as=0.13165 ps=1.14 w=0.65 l=0.15
X7 a_109_47# A a_27_47# VNB sky130_fd_pr__nfet_01v8 ad=0.0441 pd=0.63 as=0.1092 ps=1.36 w=0.42 l=0.15
.ends

.subckt sky130_fd_sc_hd__decap_4 VGND VPWR VPB VNB
X0 VPWR VGND VPWR VPB sky130_fd_pr__pfet_01v8_hvt ad=0.2262 pd=2.26 as=0 ps=0 w=0.87 l=1.05
X1 VGND VPWR VGND VNB sky130_fd_pr__nfet_01v8 ad=0.143 pd=1.62 as=0 ps=0 w=0.55 l=1.05
.ends

.subckt sky130_fd_sc_hd__or2_1 VPB VNB VGND VPWR X A B
X0 VGND A a_68_297# VNB sky130_fd_pr__nfet_01v8 ad=0.10025 pd=0.985 as=0.0567 ps=0.69 w=0.42 l=0.15
X1 a_68_297# B VGND VNB sky130_fd_pr__nfet_01v8 ad=0.0567 pd=0.69 as=0.1092 ps=1.36 w=0.42 l=0.15
X2 X a_68_297# VGND VNB sky130_fd_pr__nfet_01v8 ad=0.169 pd=1.82 as=0.10025 ps=0.985 w=0.65 l=0.15
X3 VPWR A a_150_297# VPB sky130_fd_pr__pfet_01v8_hvt ad=0.14575 pd=1.335 as=0.0441 ps=0.63 w=0.42 l=0.15
X4 X a_68_297# VPWR VPB sky130_fd_pr__pfet_01v8_hvt ad=0.34 pd=2.68 as=0.14575 ps=1.335 w=1 l=0.15
X5 a_150_297# B a_68_297# VPB sky130_fd_pr__pfet_01v8_hvt ad=0.0441 pd=0.63 as=0.1092 ps=1.36 w=0.42 l=0.15
.ends

.subckt sky130_fd_sc_hd__clkinv_2 VNB VPB VPWR VGND A Y
X0 Y A VGND VNB sky130_fd_pr__nfet_01v8 ad=0.0588 pd=0.7 as=0.1113 ps=1.37 w=0.42 l=0.15
X1 Y A VPWR VPB sky130_fd_pr__pfet_01v8_hvt ad=0.14 pd=1.28 as=0.14 ps=1.28 w=1 l=0.15
X2 VPWR A Y VPB sky130_fd_pr__pfet_01v8_hvt ad=0.14 pd=1.28 as=0.265 ps=2.53 w=1 l=0.15
X3 VGND A Y VNB sky130_fd_pr__nfet_01v8 ad=0.1092 pd=1.36 as=0.0588 ps=0.7 w=0.42 l=0.15
X4 VPWR A Y VPB sky130_fd_pr__pfet_01v8_hvt ad=0.265 pd=2.53 as=0.14 ps=1.28 w=1 l=0.15
.ends

.subckt sky130_fd_sc_hd__or3b_1 VGND VPWR VPB VNB B C_N A X
X0 a_109_93# C_N VGND VNB sky130_fd_pr__nfet_01v8 ad=0.1092 pd=1.36 as=0.1092 ps=1.36 w=0.42 l=0.15
X1 a_215_53# B VGND VNB sky130_fd_pr__nfet_01v8 ad=0.0567 pd=0.69 as=0.0567 ps=0.69 w=0.42 l=0.15
X2 VGND a_109_93# a_215_53# VNB sky130_fd_pr__nfet_01v8 ad=0.0567 pd=0.69 as=0.1092 ps=1.36 w=0.42 l=0.15
X3 VGND A a_215_53# VNB sky130_fd_pr__nfet_01v8 ad=0.10025 pd=0.985 as=0.0567 ps=0.69 w=0.42 l=0.15
X4 VPWR A a_369_297# VPB sky130_fd_pr__pfet_01v8_hvt ad=0.14825 pd=1.34 as=0.06825 ps=0.745 w=0.42 l=0.15
X5 a_369_297# B a_297_297# VPB sky130_fd_pr__pfet_01v8_hvt ad=0.06825 pd=0.745 as=0.0441 ps=0.63 w=0.42 l=0.15
X6 X a_215_53# VPWR VPB sky130_fd_pr__pfet_01v8_hvt ad=0.275 pd=2.55 as=0.14825 ps=1.34 w=1 l=0.15
X7 a_297_297# a_109_93# a_215_53# VPB sky130_fd_pr__pfet_01v8_hvt ad=0.0441 pd=0.63 as=0.1092 ps=1.36 w=0.42 l=0.15
X8 a_109_93# C_N VPWR VPB sky130_fd_pr__pfet_01v8_hvt ad=0.1092 pd=1.36 as=0.1092 ps=1.36 w=0.42 l=0.15
X9 X a_215_53# VGND VNB sky130_fd_pr__nfet_01v8 ad=0.17875 pd=1.85 as=0.10025 ps=0.985 w=0.65 l=0.15
.ends

.subckt sky130_fd_sc_hd__inv_2 VPB VNB VPWR VGND Y A
X0 Y A VPWR VPB sky130_fd_pr__pfet_01v8_hvt ad=0.135 pd=1.27 as=0.26 ps=2.52 w=1 l=0.15
X1 VGND A Y VNB sky130_fd_pr__nfet_01v8 ad=0.169 pd=1.82 as=0.08775 ps=0.92 w=0.65 l=0.15
X2 Y A VGND VNB sky130_fd_pr__nfet_01v8 ad=0.08775 pd=0.92 as=0.169 ps=1.82 w=0.65 l=0.15
X3 VPWR A Y VPB sky130_fd_pr__pfet_01v8_hvt ad=0.26 pd=2.52 as=0.135 ps=1.27 w=1 l=0.15
.ends

.subckt sky130_fd_sc_hd__a21boi_1 VPWR VGND VPB VNB B1_N Y A1 A2
X0 a_300_297# a_27_413# Y VPB sky130_fd_pr__pfet_01v8_hvt ad=0.14 pd=1.28 as=0.265 ps=2.53 w=1 l=0.15
X1 VGND A2 a_384_47# VNB sky130_fd_pr__nfet_01v8 ad=0.17225 pd=1.83 as=0.091 ps=0.93 w=0.65 l=0.15
X2 VPWR B1_N a_27_413# VPB sky130_fd_pr__pfet_01v8_hvt ad=0.1113 pd=1.37 as=0.1113 ps=1.37 w=0.42 l=0.15
X3 Y a_27_413# VGND VNB sky130_fd_pr__nfet_01v8 ad=0.143 pd=1.09 as=0.10187 ps=0.99 w=0.65 l=0.15
X4 VPWR A1 a_300_297# VPB sky130_fd_pr__pfet_01v8_hvt ad=0.14 pd=1.28 as=0.14 ps=1.28 w=1 l=0.15
X5 a_384_47# A1 Y VNB sky130_fd_pr__nfet_01v8 ad=0.091 pd=0.93 as=0.143 ps=1.09 w=0.65 l=0.15
X6 VGND B1_N a_27_413# VNB sky130_fd_pr__nfet_01v8 ad=0.10187 pd=0.99 as=0.1113 ps=1.37 w=0.42 l=0.15
X7 a_300_297# A2 VPWR VPB sky130_fd_pr__pfet_01v8_hvt ad=0.265 pd=2.53 as=0.14 ps=1.28 w=1 l=0.15
.ends

.subckt sky130_fd_sc_hd__o21ai_1 VGND VPWR A2 B1 Y A1 VPB VNB
X0 Y A2 a_109_297# VPB sky130_fd_pr__pfet_01v8_hvt ad=0.174 pd=1.39 as=0.105 ps=1.21 w=1 l=0.15
X1 VPWR B1 Y VPB sky130_fd_pr__pfet_01v8_hvt ad=0.182 pd=1.92 as=0.174 ps=1.39 w=0.7 l=0.15
X2 a_27_47# A2 VGND VNB sky130_fd_pr__nfet_01v8 ad=0.08775 pd=0.92 as=0.10725 ps=0.98 w=0.65 l=0.15
X3 Y B1 a_27_47# VNB sky130_fd_pr__nfet_01v8 ad=0.169 pd=1.82 as=0.08775 ps=0.92 w=0.65 l=0.15
X4 a_109_297# A1 VPWR VPB sky130_fd_pr__pfet_01v8_hvt ad=0.105 pd=1.21 as=0.26 ps=2.52 w=1 l=0.15
X5 VGND A1 a_27_47# VNB sky130_fd_pr__nfet_01v8 ad=0.10725 pd=0.98 as=0.169 ps=1.82 w=0.65 l=0.15
.ends

.subckt sky130_fd_sc_hd__xor2_1 VNB VPB VPWR VGND A X B
X0 X a_35_297# a_285_297# VPB sky130_fd_pr__pfet_01v8_hvt ad=0.3 pd=2.6 as=0.26 ps=2.52 w=1 l=0.15
X1 X B a_285_47# VNB sky130_fd_pr__nfet_01v8 ad=0.25025 pd=1.42 as=0.08775 ps=0.92 w=0.65 l=0.15
X2 a_35_297# B VGND VNB sky130_fd_pr__nfet_01v8 ad=0.08775 pd=0.92 as=0.169 ps=1.82 w=0.65 l=0.15
X3 a_117_297# B a_35_297# VPB sky130_fd_pr__pfet_01v8_hvt ad=0.135 pd=1.27 as=0.26 ps=2.52 w=1 l=0.15
X4 VPWR B a_285_297# VPB sky130_fd_pr__pfet_01v8_hvt ad=0.26 pd=2.52 as=0.135 ps=1.27 w=1 l=0.15
X5 VGND A a_35_297# VNB sky130_fd_pr__nfet_01v8 ad=0.08775 pd=0.92 as=0.08775 ps=0.92 w=0.65 l=0.15
X6 VGND a_35_297# X VNB sky130_fd_pr__nfet_01v8 ad=0.208 pd=1.94 as=0.25025 ps=1.42 w=0.65 l=0.15
X7 a_285_297# A VPWR VPB sky130_fd_pr__pfet_01v8_hvt ad=0.135 pd=1.27 as=0.135 ps=1.27 w=1 l=0.15
X8 VPWR A a_117_297# VPB sky130_fd_pr__pfet_01v8_hvt ad=0.135 pd=1.27 as=0.135 ps=1.27 w=1 l=0.15
X9 a_285_47# A VGND VNB sky130_fd_pr__nfet_01v8 ad=0.08775 pd=0.92 as=0.08775 ps=0.92 w=0.65 l=0.15
.ends

.subckt sky130_fd_sc_hd__or4_1 VPWR VGND VPB VNB B D C A X
X0 a_27_297# B VGND VNB sky130_fd_pr__nfet_01v8 ad=0.0567 pd=0.69 as=0.0567 ps=0.69 w=0.42 l=0.15
X1 a_27_297# D VGND VNB sky130_fd_pr__nfet_01v8 ad=0.0693 pd=0.75 as=0.1092 ps=1.36 w=0.42 l=0.15
X2 a_277_297# B a_205_297# VPB sky130_fd_pr__pfet_01v8_hvt ad=0.0693 pd=0.75 as=0.0441 ps=0.63 w=0.42 l=0.15
X3 VPWR A a_277_297# VPB sky130_fd_pr__pfet_01v8_hvt ad=0.14825 pd=1.34 as=0.0693 ps=0.75 w=0.42 l=0.15
X4 X a_27_297# VGND VNB sky130_fd_pr__nfet_01v8 ad=0.1755 pd=1.84 as=0.10187 ps=0.99 w=0.65 l=0.15
X5 a_205_297# C a_109_297# VPB sky130_fd_pr__pfet_01v8_hvt ad=0.0441 pd=0.63 as=0.0693 ps=0.75 w=0.42 l=0.15
X6 X a_27_297# VPWR VPB sky130_fd_pr__pfet_01v8_hvt ad=0.27 pd=2.54 as=0.14825 ps=1.34 w=1 l=0.15
X7 VGND C a_27_297# VNB sky130_fd_pr__nfet_01v8 ad=0.0567 pd=0.69 as=0.0693 ps=0.75 w=0.42 l=0.15
X8 a_109_297# D a_27_297# VPB sky130_fd_pr__pfet_01v8_hvt ad=0.0693 pd=0.75 as=0.1092 ps=1.36 w=0.42 l=0.15
X9 VGND A a_27_297# VNB sky130_fd_pr__nfet_01v8 ad=0.10187 pd=0.99 as=0.0567 ps=0.69 w=0.42 l=0.15
.ends

.subckt sky130_fd_sc_hd__a21bo_1 VNB VPB VGND VPWR X A2 A1 B1_N
X0 a_298_297# a_27_413# a_215_297# VPB sky130_fd_pr__pfet_01v8_hvt ad=0.135 pd=1.27 as=0.265 ps=2.53 w=1 l=0.15
X1 a_215_297# a_27_413# VGND VNB sky130_fd_pr__nfet_01v8 ad=0.08775 pd=0.92 as=0.1359 ps=1.1 w=0.65 l=0.15
X2 a_298_297# A2 VPWR VPB sky130_fd_pr__pfet_01v8_hvt ad=0.265 pd=2.53 as=0.14 ps=1.28 w=1 l=0.15
X3 X a_215_297# VGND VNB sky130_fd_pr__nfet_01v8 ad=0.169 pd=1.82 as=0.25837 ps=1.445 w=0.65 l=0.15
X4 VPWR B1_N a_27_413# VPB sky130_fd_pr__pfet_01v8_hvt ad=0.1092 pd=1.36 as=0.1092 ps=1.36 w=0.42 l=0.15
X5 X a_215_297# VPWR VPB sky130_fd_pr__pfet_01v8_hvt ad=0.26 pd=2.52 as=0.26 ps=2.52 w=1 l=0.15
X6 a_382_47# A1 a_215_297# VNB sky130_fd_pr__nfet_01v8 ad=0.091 pd=0.93 as=0.08775 ps=0.92 w=0.65 l=0.15
X7 VGND B1_N a_27_413# VNB sky130_fd_pr__nfet_01v8 ad=0.1359 pd=1.1 as=0.1113 ps=1.37 w=0.42 l=0.15
X8 VPWR A1 a_298_297# VPB sky130_fd_pr__pfet_01v8_hvt ad=0.14 pd=1.28 as=0.135 ps=1.27 w=1 l=0.15
X9 VGND A2 a_382_47# VNB sky130_fd_pr__nfet_01v8 ad=0.25837 pd=1.445 as=0.091 ps=0.93 w=0.65 l=0.15
.ends

.subckt sky130_fd_sc_hd__a31o_1 VPB VNB X A3 A2 A1 B1 VGND VPWR
X0 VPWR a_80_21# X VPB sky130_fd_pr__pfet_01v8_hvt ad=0.1725 pd=1.345 as=0.265 ps=2.53 w=1 l=0.15
X1 a_209_297# A3 VPWR VPB sky130_fd_pr__pfet_01v8_hvt ad=0.16 pd=1.32 as=0.1725 ps=1.345 w=1 l=0.15
X2 a_303_47# A2 a_209_47# VNB sky130_fd_pr__nfet_01v8 ad=0.10725 pd=0.98 as=0.104 ps=0.97 w=0.65 l=0.15
X3 a_209_47# A3 VGND VNB sky130_fd_pr__nfet_01v8 ad=0.104 pd=0.97 as=0.11213 ps=0.995 w=0.65 l=0.15
X4 VGND a_80_21# X VNB sky130_fd_pr__nfet_01v8 ad=0.11213 pd=0.995 as=0.17225 ps=1.83 w=0.65 l=0.15
X5 VGND B1 a_80_21# VNB sky130_fd_pr__nfet_01v8 ad=0.208 pd=1.94 as=0.10725 ps=0.98 w=0.65 l=0.15
X6 a_80_21# A1 a_303_47# VNB sky130_fd_pr__nfet_01v8 ad=0.10725 pd=0.98 as=0.10725 ps=0.98 w=0.65 l=0.15
X7 VPWR A2 a_209_297# VPB sky130_fd_pr__pfet_01v8_hvt ad=0.165 pd=1.33 as=0.16 ps=1.32 w=1 l=0.15
X8 a_80_21# B1 a_209_297# VPB sky130_fd_pr__pfet_01v8_hvt ad=0.32 pd=2.64 as=0.165 ps=1.33 w=1 l=0.15
X9 a_209_297# A1 VPWR VPB sky130_fd_pr__pfet_01v8_hvt ad=0.165 pd=1.33 as=0.165 ps=1.33 w=1 l=0.15
.ends

.subckt sky130_fd_sc_hd__or3_1 VPWR VGND VPB VNB B C A X
X0 X a_29_53# VPWR VPB sky130_fd_pr__pfet_01v8_hvt ad=0.28 pd=2.56 as=0.14825 ps=1.34 w=1 l=0.15
X1 a_111_297# C a_29_53# VPB sky130_fd_pr__pfet_01v8_hvt ad=0.0441 pd=0.63 as=0.1092 ps=1.36 w=0.42 l=0.15
X2 X a_29_53# VGND VNB sky130_fd_pr__nfet_01v8 ad=0.182 pd=1.86 as=0.10187 ps=0.99 w=0.65 l=0.15
X3 a_183_297# B a_111_297# VPB sky130_fd_pr__pfet_01v8_hvt ad=0.0693 pd=0.75 as=0.0441 ps=0.63 w=0.42 l=0.15
X4 VPWR A a_183_297# VPB sky130_fd_pr__pfet_01v8_hvt ad=0.14825 pd=1.34 as=0.0693 ps=0.75 w=0.42 l=0.15
X5 a_29_53# B VGND VNB sky130_fd_pr__nfet_01v8 ad=0.0567 pd=0.69 as=0.0567 ps=0.69 w=0.42 l=0.15
X6 VGND C a_29_53# VNB sky130_fd_pr__nfet_01v8 ad=0.0567 pd=0.69 as=0.1092 ps=1.36 w=0.42 l=0.15
X7 VGND A a_29_53# VNB sky130_fd_pr__nfet_01v8 ad=0.10187 pd=0.99 as=0.0567 ps=0.69 w=0.42 l=0.15
.ends

.subckt sky130_fd_sc_hd__nand3_1 VPB VNB VGND VPWR A B Y C
X0 VPWR B Y VPB sky130_fd_pr__pfet_01v8_hvt ad=0.165 pd=1.33 as=0.135 ps=1.27 w=1 l=0.15
X1 Y A VPWR VPB sky130_fd_pr__pfet_01v8_hvt ad=0.26 pd=2.52 as=0.165 ps=1.33 w=1 l=0.15
X2 a_193_47# B a_109_47# VNB sky130_fd_pr__nfet_01v8 ad=0.10725 pd=0.98 as=0.08775 ps=0.92 w=0.65 l=0.15
X3 Y A a_193_47# VNB sky130_fd_pr__nfet_01v8 ad=0.169 pd=1.82 as=0.10725 ps=0.98 w=0.65 l=0.15
X4 Y C VPWR VPB sky130_fd_pr__pfet_01v8_hvt ad=0.135 pd=1.27 as=0.26 ps=2.52 w=1 l=0.15
X5 a_109_47# C VGND VNB sky130_fd_pr__nfet_01v8 ad=0.08775 pd=0.92 as=0.169 ps=1.82 w=0.65 l=0.15
.ends

.subckt sky130_fd_sc_hd__o21a_1 VPB VNB VGND VPWR A1 A2 B1 X
X0 VPWR A1 a_382_297# VPB sky130_fd_pr__pfet_01v8_hvt ad=0.26 pd=2.52 as=0.1525 ps=1.305 w=1 l=0.15
X1 a_297_47# B1 a_79_21# VNB sky130_fd_pr__nfet_01v8 ad=0.10075 pd=0.96 as=0.169 ps=1.82 w=0.65 l=0.15
X2 a_297_47# A1 VGND VNB sky130_fd_pr__nfet_01v8 ad=0.169 pd=1.82 as=0.08775 ps=0.92 w=0.65 l=0.15
X3 VGND A2 a_297_47# VNB sky130_fd_pr__nfet_01v8 ad=0.08775 pd=0.92 as=0.10075 ps=0.96 w=0.65 l=0.15
X4 VPWR a_79_21# X VPB sky130_fd_pr__pfet_01v8_hvt ad=0.3275 pd=1.655 as=0.28 ps=2.56 w=1 l=0.15
X5 a_79_21# B1 VPWR VPB sky130_fd_pr__pfet_01v8_hvt ad=0.195 pd=1.39 as=0.3275 ps=1.655 w=1 l=0.15
X6 a_382_297# A2 a_79_21# VPB sky130_fd_pr__pfet_01v8_hvt ad=0.1525 pd=1.305 as=0.195 ps=1.39 w=1 l=0.15
X7 VGND a_79_21# X VNB sky130_fd_pr__nfet_01v8 ad=0.169 pd=1.82 as=0.169 ps=1.82 w=0.65 l=0.15
.ends

.subckt sky130_fd_sc_hd__a21oi_1 VPWR VGND VPB VNB A2 A1 B1 Y
X0 a_199_47# A1 Y VNB sky130_fd_pr__nfet_01v8 ad=0.09588 pd=0.945 as=0.091 ps=0.93 w=0.65 l=0.15
X1 a_113_297# A2 VPWR VPB sky130_fd_pr__pfet_01v8_hvt ad=0.265 pd=2.53 as=0.1475 ps=1.295 w=1 l=0.15
X2 Y B1 VGND VNB sky130_fd_pr__nfet_01v8 ad=0.091 pd=0.93 as=0.17225 ps=1.83 w=0.65 l=0.15
X3 VPWR A1 a_113_297# VPB sky130_fd_pr__pfet_01v8_hvt ad=0.1475 pd=1.295 as=0.14 ps=1.28 w=1 l=0.15
X4 a_113_297# B1 Y VPB sky130_fd_pr__pfet_01v8_hvt ad=0.14 pd=1.28 as=0.265 ps=2.53 w=1 l=0.15
X5 VGND A2 a_199_47# VNB sky130_fd_pr__nfet_01v8 ad=0.17225 pd=1.83 as=0.09588 ps=0.945 w=0.65 l=0.15
.ends

.subckt sky130_fd_sc_hd__clkbuf_1 VGND VPWR X A VPB VNB
X0 VPWR a_75_212# X VPB sky130_fd_pr__pfet_01v8_hvt ad=0.11455 pd=1.08 as=0.2054 ps=2.1 w=0.79 l=0.15
X1 a_75_212# A VGND VNB sky130_fd_pr__nfet_01v8 ad=0.1352 pd=1.56 as=0.0754 ps=0.81 w=0.52 l=0.15
X2 a_75_212# A VPWR VPB sky130_fd_pr__pfet_01v8_hvt ad=0.2054 pd=2.1 as=0.11455 ps=1.08 w=0.79 l=0.15
X3 VGND a_75_212# X VNB sky130_fd_pr__nfet_01v8 ad=0.0754 pd=0.81 as=0.1352 ps=1.56 w=0.52 l=0.15
.ends

.subckt sky130_fd_sc_hd__dfxtp_2 Q CLK D VPB VNB VPWR VGND
X0 Q a_1059_315# VGND VNB sky130_fd_pr__nfet_01v8 ad=0.08775 pd=0.92 as=0.08775 ps=0.92 w=0.65 l=0.15
X1 a_891_413# a_193_47# a_634_159# VNB sky130_fd_pr__nfet_01v8 ad=0.0684 pd=0.74 as=0.0989 ps=0.995 w=0.36 l=0.15
X2 VPWR a_1059_315# Q VPB sky130_fd_pr__pfet_01v8_hvt ad=0.26 pd=2.52 as=0.135 ps=1.27 w=1 l=0.15
X3 a_561_413# a_27_47# a_466_413# VPB sky130_fd_pr__pfet_01v8_hvt ad=0.07665 pd=0.785 as=0.06825 ps=0.745 w=0.42 l=0.15
X4 VPWR CLK a_27_47# VPB sky130_fd_pr__pfet_01v8_hvt ad=0.0864 pd=0.91 as=0.1664 ps=1.8 w=0.64 l=0.15
X5 Q a_1059_315# VPWR VPB sky130_fd_pr__pfet_01v8_hvt ad=0.135 pd=1.27 as=0.135 ps=1.27 w=1 l=0.15
X6 a_381_47# D VPWR VPB sky130_fd_pr__pfet_01v8_hvt ad=0.05775 pd=0.695 as=0.1092 ps=1.36 w=0.42 l=0.15
X7 VGND a_634_159# a_592_47# VNB sky130_fd_pr__nfet_01v8 ad=0.12095 pd=1.085 as=0.0696 ps=0.765 w=0.42 l=0.15
X8 VGND a_1059_315# Q VNB sky130_fd_pr__nfet_01v8 ad=0.169 pd=1.82 as=0.08775 ps=0.92 w=0.65 l=0.15
X9 VPWR a_891_413# a_1059_315# VPB sky130_fd_pr__pfet_01v8_hvt ad=0.135 pd=1.27 as=0.27 ps=2.54 w=1 l=0.15
X10 a_466_413# a_193_47# a_381_47# VPB sky130_fd_pr__pfet_01v8_hvt ad=0.06825 pd=0.745 as=0.05775 ps=0.695 w=0.42 l=0.15
X11 VPWR a_634_159# a_561_413# VPB sky130_fd_pr__pfet_01v8_hvt ad=0.17887 pd=1.26 as=0.07665 ps=0.785 w=0.42 l=0.15
X12 a_634_159# a_466_413# VGND VNB sky130_fd_pr__nfet_01v8 ad=0.0989 pd=0.995 as=0.12095 ps=1.085 w=0.64 l=0.15
X13 a_634_159# a_466_413# VPWR VPB sky130_fd_pr__pfet_01v8_hvt ad=0.1095 pd=1.075 as=0.17887 ps=1.26 w=0.75 l=0.15
X14 a_975_413# a_193_47# a_891_413# VPB sky130_fd_pr__pfet_01v8_hvt ad=0.0882 pd=0.84 as=0.0567 ps=0.69 w=0.42 l=0.15
X15 VGND a_1059_315# a_1017_47# VNB sky130_fd_pr__nfet_01v8 ad=0.1092 pd=1.36 as=0.066 ps=0.745 w=0.42 l=0.15
X16 a_193_47# a_27_47# VGND VNB sky130_fd_pr__nfet_01v8 ad=0.1092 pd=1.36 as=0.0567 ps=0.69 w=0.42 l=0.15
X17 a_891_413# a_27_47# a_634_159# VPB sky130_fd_pr__pfet_01v8_hvt ad=0.0567 pd=0.69 as=0.1095 ps=1.075 w=0.42 l=0.15
X18 a_592_47# a_193_47# a_466_413# VNB sky130_fd_pr__nfet_01v8 ad=0.0696 pd=0.765 as=0.0621 ps=0.705 w=0.36 l=0.15
X19 a_1017_47# a_27_47# a_891_413# VNB sky130_fd_pr__nfet_01v8 ad=0.066 pd=0.745 as=0.0684 ps=0.74 w=0.36 l=0.15
X20 VPWR a_1059_315# a_975_413# VPB sky130_fd_pr__pfet_01v8_hvt ad=0.1113 pd=1.37 as=0.0882 ps=0.84 w=0.42 l=0.15
X21 a_466_413# a_27_47# a_381_47# VNB sky130_fd_pr__nfet_01v8 ad=0.0621 pd=0.705 as=0.0813 ps=0.83 w=0.36 l=0.15
X22 a_193_47# a_27_47# VPWR VPB sky130_fd_pr__pfet_01v8_hvt ad=0.1664 pd=1.8 as=0.0864 ps=0.91 w=0.64 l=0.15
X23 VGND a_891_413# a_1059_315# VNB sky130_fd_pr__nfet_01v8 ad=0.08775 pd=0.92 as=0.169 ps=1.82 w=0.65 l=0.15
X24 a_381_47# D VGND VNB sky130_fd_pr__nfet_01v8 ad=0.0813 pd=0.83 as=0.1092 ps=1.36 w=0.42 l=0.15
X25 VGND CLK a_27_47# VNB sky130_fd_pr__nfet_01v8 ad=0.0567 pd=0.69 as=0.1092 ps=1.36 w=0.42 l=0.15
.ends

.subckt sky130_fd_sc_hd__and2b_1 X A_N B VGND VPWR VPB VNB
X0 VPWR B a_207_413# VPB sky130_fd_pr__pfet_01v8_hvt ad=0.2279 pd=1.74 as=0.0609 ps=0.71 w=0.42 l=0.15
X1 X a_207_413# VPWR VPB sky130_fd_pr__pfet_01v8_hvt ad=0.26 pd=2.52 as=0.2279 ps=1.74 w=1 l=0.15
X2 a_297_47# a_27_413# a_207_413# VNB sky130_fd_pr__nfet_01v8 ad=0.0504 pd=0.66 as=0.1092 ps=1.36 w=0.42 l=0.15
X3 X a_207_413# VGND VNB sky130_fd_pr__nfet_01v8 ad=0.169 pd=1.82 as=0.1013 ps=0.99 w=0.65 l=0.15
X4 a_207_413# a_27_413# VPWR VPB sky130_fd_pr__pfet_01v8_hvt ad=0.0609 pd=0.71 as=0.0714 ps=0.76 w=0.42 l=0.15
X5 VPWR A_N a_27_413# VPB sky130_fd_pr__pfet_01v8_hvt ad=0.0714 pd=0.76 as=0.1092 ps=1.36 w=0.42 l=0.15
X6 VGND B a_297_47# VNB sky130_fd_pr__nfet_01v8 ad=0.1013 pd=0.99 as=0.0504 ps=0.66 w=0.42 l=0.15
X7 a_27_413# A_N VGND VNB sky130_fd_pr__nfet_01v8 ad=0.1092 pd=1.36 as=0.1092 ps=1.36 w=0.42 l=0.15
.ends

.subckt sky130_fd_sc_hd__dfxtp_4 VGND VPWR VNB VPB Q D CLK
X0 Q a_1062_300# VPWR VPB sky130_fd_pr__pfet_01v8_hvt ad=0.135 pd=1.27 as=0.1425 ps=1.285 w=1 l=0.15
X1 a_1020_47# a_27_47# a_891_413# VNB sky130_fd_pr__nfet_01v8 ad=0.066 pd=0.745 as=0.0657 ps=0.725 w=0.36 l=0.15
X2 a_572_47# a_193_47# a_475_413# VNB sky130_fd_pr__nfet_01v8 ad=0.0687 pd=0.76 as=0.0594 ps=0.69 w=0.36 l=0.15
X3 VPWR a_1062_300# a_975_413# VPB sky130_fd_pr__pfet_01v8_hvt ad=0.1218 pd=1.42 as=0.09135 ps=0.855 w=0.42 l=0.15
X4 a_634_183# a_475_413# VGND VNB sky130_fd_pr__nfet_01v8 ad=0.0989 pd=0.995 as=0.1493 ps=1.22 w=0.64 l=0.15
X5 VPWR CLK a_27_47# VPB sky130_fd_pr__pfet_01v8_hvt ad=0.0864 pd=0.91 as=0.1664 ps=1.8 w=0.64 l=0.15
X6 a_381_47# D VPWR VPB sky130_fd_pr__pfet_01v8_hvt ad=0.0672 pd=0.74 as=0.1092 ps=1.36 w=0.42 l=0.15
X7 a_475_413# a_27_47# a_381_47# VNB sky130_fd_pr__nfet_01v8 ad=0.0594 pd=0.69 as=0.066 ps=0.745 w=0.36 l=0.15
X8 VGND a_1062_300# a_1020_47# VNB sky130_fd_pr__nfet_01v8 ad=0.1197 pd=1.41 as=0.066 ps=0.745 w=0.42 l=0.15
X9 VPWR a_634_183# a_568_413# VPB sky130_fd_pr__pfet_01v8_hvt ad=0.17887 pd=1.26 as=0.0693 ps=0.75 w=0.42 l=0.15
X10 Q a_1062_300# VGND VNB sky130_fd_pr__nfet_01v8 ad=0.08775 pd=0.92 as=0.09262 ps=0.935 w=0.65 l=0.15
X11 a_568_413# a_27_47# a_475_413# VPB sky130_fd_pr__pfet_01v8_hvt ad=0.0693 pd=0.75 as=0.06615 ps=0.735 w=0.42 l=0.15
X12 a_634_183# a_475_413# VPWR VPB sky130_fd_pr__pfet_01v8_hvt ad=0.1095 pd=1.075 as=0.17887 ps=1.26 w=0.75 l=0.15
X13 a_975_413# a_193_47# a_891_413# VPB sky130_fd_pr__pfet_01v8_hvt ad=0.09135 pd=0.855 as=0.0567 ps=0.69 w=0.42 l=0.15
X14 a_193_47# a_27_47# VGND VNB sky130_fd_pr__nfet_01v8 ad=0.1092 pd=1.36 as=0.0567 ps=0.69 w=0.42 l=0.15
X15 a_891_413# a_27_47# a_634_183# VPB sky130_fd_pr__pfet_01v8_hvt ad=0.0567 pd=0.69 as=0.1095 ps=1.075 w=0.42 l=0.15
X16 Q a_1062_300# VGND VNB sky130_fd_pr__nfet_01v8 ad=0.08775 pd=0.92 as=0.10563 ps=0.975 w=0.65 l=0.15
X17 VGND a_891_413# a_1062_300# VNB sky130_fd_pr__nfet_01v8 ad=0.10563 pd=0.975 as=0.169 ps=1.82 w=0.65 l=0.15
X18 VPWR a_1062_300# Q VPB sky130_fd_pr__pfet_01v8_hvt ad=0.1425 pd=1.285 as=0.135 ps=1.27 w=1 l=0.15
X19 VGND a_1062_300# Q VNB sky130_fd_pr__nfet_01v8 ad=0.18525 pd=1.87 as=0.08775 ps=0.92 w=0.65 l=0.15
X20 Q a_1062_300# VPWR VPB sky130_fd_pr__pfet_01v8_hvt ad=0.135 pd=1.27 as=0.1625 ps=1.325 w=1 l=0.15
X21 a_193_47# a_27_47# VPWR VPB sky130_fd_pr__pfet_01v8_hvt ad=0.1664 pd=1.8 as=0.0864 ps=0.91 w=0.64 l=0.15
X22 VGND a_1062_300# Q VNB sky130_fd_pr__nfet_01v8 ad=0.09262 pd=0.935 as=0.08775 ps=0.92 w=0.65 l=0.15
X23 a_381_47# D VGND VNB sky130_fd_pr__nfet_01v8 ad=0.066 pd=0.745 as=0.1092 ps=1.36 w=0.42 l=0.15
X24 VPWR a_891_413# a_1062_300# VPB sky130_fd_pr__pfet_01v8_hvt ad=0.1625 pd=1.325 as=0.28 ps=2.56 w=1 l=0.15
X25 a_891_413# a_193_47# a_634_183# VNB sky130_fd_pr__nfet_01v8 ad=0.0657 pd=0.725 as=0.0989 ps=0.995 w=0.36 l=0.15
X26 a_475_413# a_193_47# a_381_47# VPB sky130_fd_pr__pfet_01v8_hvt ad=0.06615 pd=0.735 as=0.0672 ps=0.74 w=0.42 l=0.15
X27 VGND a_634_183# a_572_47# VNB sky130_fd_pr__nfet_01v8 ad=0.1493 pd=1.22 as=0.0687 ps=0.76 w=0.42 l=0.15
X28 VGND CLK a_27_47# VNB sky130_fd_pr__nfet_01v8 ad=0.0567 pd=0.69 as=0.1092 ps=1.36 w=0.42 l=0.15
X29 VPWR a_1062_300# Q VPB sky130_fd_pr__pfet_01v8_hvt ad=0.28 pd=2.56 as=0.135 ps=1.27 w=1 l=0.15
.ends

.subckt sky130_fd_sc_hd__a31oi_1 VGND VPWR VPB VNB A3 A2 A1 Y B1
X0 Y A1 a_181_47# VNB sky130_fd_pr__nfet_01v8 ad=0.10563 pd=0.975 as=0.11863 ps=1.015 w=0.65 l=0.15
X1 a_181_47# A2 a_109_47# VNB sky130_fd_pr__nfet_01v8 ad=0.11863 pd=1.015 as=0.06825 ps=0.86 w=0.65 l=0.15
X2 VGND B1 Y VNB sky130_fd_pr__nfet_01v8 ad=0.1755 pd=1.84 as=0.10563 ps=0.975 w=0.65 l=0.15
X3 VPWR A2 a_109_297# VPB sky130_fd_pr__pfet_01v8_hvt ad=0.1525 pd=1.305 as=0.135 ps=1.27 w=1 l=0.15
X4 Y B1 a_109_297# VPB sky130_fd_pr__pfet_01v8_hvt ad=0.27 pd=2.54 as=0.1625 ps=1.325 w=1 l=0.15
X5 a_109_297# A1 VPWR VPB sky130_fd_pr__pfet_01v8_hvt ad=0.1625 pd=1.325 as=0.1525 ps=1.305 w=1 l=0.15
X6 a_109_297# A3 VPWR VPB sky130_fd_pr__pfet_01v8_hvt ad=0.135 pd=1.27 as=0.26 ps=2.52 w=1 l=0.15
X7 a_109_47# A3 VGND VNB sky130_fd_pr__nfet_01v8 ad=0.06825 pd=0.86 as=0.169 ps=1.82 w=0.65 l=0.15
.ends

.subckt sky130_fd_sc_hd__dlclkp_1 VGND VPWR GCLK GATE CLK VPB VNB
X0 a_381_369# GATE VPWR VPB sky130_fd_pr__pfet_01v8_hvt ad=0.09575 pd=0.965 as=0.1664 ps=1.8 w=0.64 l=0.15
X1 a_476_413# a_193_47# a_381_369# VPB sky130_fd_pr__pfet_01v8_hvt ad=0.0987 pd=0.89 as=0.09575 ps=0.965 w=0.42 l=0.15
X2 a_957_369# a_642_307# VPWR VPB sky130_fd_pr__pfet_01v8_hvt ad=0.2032 pd=1.275 as=0.149 ps=1.325 w=0.64 l=0.15
X3 VPWR CLK a_27_47# VPB sky130_fd_pr__pfet_01v8_hvt ad=0.0864 pd=0.91 as=0.1664 ps=1.8 w=0.64 l=0.15
X4 a_1042_47# a_642_307# a_957_369# VNB sky130_fd_pr__nfet_01v8 ad=0.0441 pd=0.63 as=0.1092 ps=1.36 w=0.42 l=0.15
X5 GCLK a_957_369# VPWR VPB sky130_fd_pr__pfet_01v8_hvt ad=0.26 pd=2.52 as=0.149 ps=1.325 w=1 l=0.15
X6 VGND CLK a_1042_47# VNB sky130_fd_pr__nfet_01v8 ad=0.097 pd=0.975 as=0.0441 ps=0.63 w=0.42 l=0.15
X7 a_193_47# a_27_47# VGND VNB sky130_fd_pr__nfet_01v8 ad=0.1092 pd=1.36 as=0.0567 ps=0.69 w=0.42 l=0.15
X8 a_651_47# a_193_47# a_476_413# VNB sky130_fd_pr__nfet_01v8 ad=0.06713 pd=0.745 as=0.1192 ps=1.09 w=0.39 l=0.15
X9 a_193_47# a_27_47# VPWR VPB sky130_fd_pr__pfet_01v8_hvt ad=0.1664 pd=1.8 as=0.0864 ps=0.91 w=0.64 l=0.15
X10 GCLK a_957_369# VGND VNB sky130_fd_pr__nfet_01v8 ad=0.169 pd=1.82 as=0.097 ps=0.975 w=0.65 l=0.15
X11 VPWR a_642_307# a_600_413# VPB sky130_fd_pr__pfet_01v8_hvt ad=0.1092 pd=1.36 as=0.0441 ps=0.63 w=0.42 l=0.15
X12 a_476_413# a_27_47# a_396_119# VNB sky130_fd_pr__nfet_01v8 ad=0.1192 pd=1.09 as=0.11712 ps=1.085 w=0.42 l=0.15
X13 VPWR CLK a_957_369# VPB sky130_fd_pr__pfet_01v8_hvt ad=0.149 pd=1.325 as=0.2032 ps=1.275 w=0.64 l=0.15
X14 a_642_307# a_476_413# VGND VNB sky130_fd_pr__nfet_01v8 ad=0.169 pd=1.82 as=0.11812 ps=1.04 w=0.65 l=0.15
X15 a_600_413# a_27_47# a_476_413# VPB sky130_fd_pr__pfet_01v8_hvt ad=0.0441 pd=0.63 as=0.0987 ps=0.89 w=0.42 l=0.15
X16 VPWR a_476_413# a_642_307# VPB sky130_fd_pr__pfet_01v8_hvt ad=0.149 pd=1.325 as=0.27 ps=2.54 w=1 l=0.15
X17 VGND a_642_307# a_651_47# VNB sky130_fd_pr__nfet_01v8 ad=0.11812 pd=1.04 as=0.06713 ps=0.745 w=0.42 l=0.15
X18 VGND CLK a_27_47# VNB sky130_fd_pr__nfet_01v8 ad=0.0567 pd=0.69 as=0.1092 ps=1.36 w=0.42 l=0.15
X19 a_396_119# GATE VGND VNB sky130_fd_pr__nfet_01v8 ad=0.11712 pd=1.085 as=0.1281 ps=1.45 w=0.42 l=0.15
.ends

.subckt sky130_fd_sc_hd__nor2_1 VPB VNB VGND VPWR A B Y
X0 VPWR A a_109_297# VPB sky130_fd_pr__pfet_01v8_hvt ad=0.26 pd=2.52 as=0.105 ps=1.21 w=1 l=0.15
X1 VGND A Y VNB sky130_fd_pr__nfet_01v8 ad=0.169 pd=1.82 as=0.08775 ps=0.92 w=0.65 l=0.15
X2 a_109_297# B Y VPB sky130_fd_pr__pfet_01v8_hvt ad=0.105 pd=1.21 as=0.26 ps=2.52 w=1 l=0.15
X3 Y B VGND VNB sky130_fd_pr__nfet_01v8 ad=0.08775 pd=0.92 as=0.169 ps=1.82 w=0.65 l=0.15
.ends

.subckt sky130_fd_sc_hd__and4_1 X C A B D VGND VPWR VPB VNB
X0 a_27_47# C VPWR VPB sky130_fd_pr__pfet_01v8_hvt ad=0.0588 pd=0.7 as=0.0777 ps=0.79 w=0.42 l=0.15
X1 a_197_47# B a_109_47# VNB sky130_fd_pr__nfet_01v8 ad=0.0798 pd=0.8 as=0.0609 ps=0.71 w=0.42 l=0.15
X2 X a_27_47# VPWR VPB sky130_fd_pr__pfet_01v8_hvt ad=0.26 pd=2.52 as=0.31245 ps=1.68 w=1 l=0.15
X3 a_303_47# C a_197_47# VNB sky130_fd_pr__nfet_01v8 ad=0.0693 pd=0.75 as=0.0798 ps=0.8 w=0.42 l=0.15
X4 a_27_47# A VPWR VPB sky130_fd_pr__pfet_01v8_hvt ad=0.0735 pd=0.77 as=0.1092 ps=1.36 w=0.42 l=0.15
X5 VPWR D a_27_47# VPB sky130_fd_pr__pfet_01v8_hvt ad=0.31245 pd=1.68 as=0.0588 ps=0.7 w=0.42 l=0.15
X6 VGND D a_303_47# VNB sky130_fd_pr__nfet_01v8 ad=0.19627 pd=1.33 as=0.0693 ps=0.75 w=0.42 l=0.15
X7 VPWR B a_27_47# VPB sky130_fd_pr__pfet_01v8_hvt ad=0.0777 pd=0.79 as=0.0735 ps=0.77 w=0.42 l=0.15
X8 X a_27_47# VGND VNB sky130_fd_pr__nfet_01v8 ad=0.169 pd=1.82 as=0.19627 ps=1.33 w=0.65 l=0.15
X9 a_109_47# A a_27_47# VNB sky130_fd_pr__nfet_01v8 ad=0.0609 pd=0.71 as=0.1092 ps=1.36 w=0.42 l=0.15
.ends

.subckt sky130_fd_sc_hd__a211o_1 VNB VPB VGND VPWR X A2 B1 A1 C1
X0 VPWR a_80_21# X VPB sky130_fd_pr__pfet_01v8_hvt ad=0.265 pd=2.53 as=0.265 ps=2.53 w=1 l=0.15
X1 a_80_21# C1 a_472_297# VPB sky130_fd_pr__pfet_01v8_hvt ad=0.265 pd=2.53 as=0.155 ps=1.31 w=1 l=0.15
X2 VPWR A2 a_217_297# VPB sky130_fd_pr__pfet_01v8_hvt ad=0.14 pd=1.28 as=0.265 ps=2.53 w=1 l=0.15
X3 VGND B1 a_80_21# VNB sky130_fd_pr__nfet_01v8 ad=0.10075 pd=0.96 as=0.091 ps=0.93 w=0.65 l=0.15
X4 VGND a_80_21# X VNB sky130_fd_pr__nfet_01v8 ad=0.26 pd=1.45 as=0.17225 ps=1.83 w=0.65 l=0.15
X5 a_300_47# A2 VGND VNB sky130_fd_pr__nfet_01v8 ad=0.091 pd=0.93 as=0.26 ps=1.45 w=0.65 l=0.15
X6 a_217_297# A1 VPWR VPB sky130_fd_pr__pfet_01v8_hvt ad=0.14 pd=1.28 as=0.14 ps=1.28 w=1 l=0.15
X7 a_80_21# A1 a_300_47# VNB sky130_fd_pr__nfet_01v8 ad=0.091 pd=0.93 as=0.091 ps=0.93 w=0.65 l=0.15
X8 a_472_297# B1 a_217_297# VPB sky130_fd_pr__pfet_01v8_hvt ad=0.155 pd=1.31 as=0.14 ps=1.28 w=1 l=0.15
X9 a_80_21# C1 VGND VNB sky130_fd_pr__nfet_01v8 ad=0.17225 pd=1.83 as=0.10075 ps=0.96 w=0.65 l=0.15
.ends

.subckt sky130_fd_sc_hd__or4b_1 VPWR VGND VPB VNB B C A X D_N
X0 X a_215_297# VPWR VPB sky130_fd_pr__pfet_01v8_hvt ad=0.275 pd=2.55 as=0.14825 ps=1.34 w=1 l=0.15
X1 a_109_53# D_N VGND VNB sky130_fd_pr__nfet_01v8 ad=0.1092 pd=1.36 as=0.1092 ps=1.36 w=0.42 l=0.15
X2 a_215_297# a_109_53# VGND VNB sky130_fd_pr__nfet_01v8 ad=0.06405 pd=0.725 as=0.1092 ps=1.36 w=0.42 l=0.15
X3 X a_215_297# VGND VNB sky130_fd_pr__nfet_01v8 ad=0.17875 pd=1.85 as=0.10187 ps=0.99 w=0.65 l=0.15
X4 a_392_297# C a_297_297# VPB sky130_fd_pr__pfet_01v8_hvt ad=0.04515 pd=0.635 as=0.06825 ps=0.745 w=0.42 l=0.15
X5 a_465_297# B a_392_297# VPB sky130_fd_pr__pfet_01v8_hvt ad=0.06405 pd=0.725 as=0.04515 ps=0.635 w=0.42 l=0.15
X6 a_215_297# B VGND VNB sky130_fd_pr__nfet_01v8 ad=0.0567 pd=0.69 as=0.0567 ps=0.69 w=0.42 l=0.15
X7 VPWR A a_465_297# VPB sky130_fd_pr__pfet_01v8_hvt ad=0.14825 pd=1.34 as=0.06405 ps=0.725 w=0.42 l=0.15
X8 a_297_297# a_109_53# a_215_297# VPB sky130_fd_pr__pfet_01v8_hvt ad=0.06825 pd=0.745 as=0.1092 ps=1.36 w=0.42 l=0.15
X9 a_109_53# D_N VPWR VPB sky130_fd_pr__pfet_01v8_hvt ad=0.1092 pd=1.36 as=0.1092 ps=1.36 w=0.42 l=0.15
X10 VGND C a_215_297# VNB sky130_fd_pr__nfet_01v8 ad=0.0567 pd=0.69 as=0.06405 ps=0.725 w=0.42 l=0.15
X11 VGND A a_215_297# VNB sky130_fd_pr__nfet_01v8 ad=0.10187 pd=0.99 as=0.0567 ps=0.69 w=0.42 l=0.15
.ends

.subckt sky130_fd_sc_hd__o21bai_1 VPB VNB VPWR VGND A1 B1_N Y A2
X0 a_388_297# A2 Y VPB sky130_fd_pr__pfet_01v8_hvt ad=0.1275 pd=1.255 as=0.1525 ps=1.305 w=1 l=0.15
X1 a_105_352# B1_N VGND VNB sky130_fd_pr__nfet_01v8 ad=0.1092 pd=1.36 as=0.1092 ps=1.36 w=0.42 l=0.15
X2 a_297_47# a_105_352# Y VNB sky130_fd_pr__nfet_01v8 ad=0.10075 pd=0.96 as=0.169 ps=1.82 w=0.65 l=0.15
X3 a_297_47# A1 VGND VNB sky130_fd_pr__nfet_01v8 ad=0.169 pd=1.82 as=0.08775 ps=0.92 w=0.65 l=0.15
X4 VPWR A1 a_388_297# VPB sky130_fd_pr__pfet_01v8_hvt ad=0.28 pd=2.56 as=0.1275 ps=1.255 w=1 l=0.15
X5 VGND A2 a_297_47# VNB sky130_fd_pr__nfet_01v8 ad=0.08775 pd=0.92 as=0.10075 ps=0.96 w=0.65 l=0.15
X6 VPWR B1_N a_105_352# VPB sky130_fd_pr__pfet_01v8_hvt ad=0.17825 pd=1.4 as=0.1092 ps=1.36 w=0.42 l=0.15
X7 Y a_105_352# VPWR VPB sky130_fd_pr__pfet_01v8_hvt ad=0.1525 pd=1.305 as=0.17825 ps=1.4 w=1 l=0.15
.ends

.subckt sky130_fd_sc_hd__o31a_1 X A1 A2 A3 B1 VPB VNB VGND VPWR
X0 a_103_199# B1 a_253_47# VNB sky130_fd_pr__nfet_01v8 ad=0.2015 pd=1.92 as=0.10725 ps=0.98 w=0.65 l=0.15
X1 VPWR a_103_199# X VPB sky130_fd_pr__pfet_01v8_hvt ad=0.195 pd=1.39 as=0.36 ps=2.72 w=1 l=0.15
X2 a_337_297# A2 a_253_297# VPB sky130_fd_pr__pfet_01v8_hvt ad=0.165 pd=1.33 as=0.135 ps=1.27 w=1 l=0.15
X3 a_103_199# A3 a_337_297# VPB sky130_fd_pr__pfet_01v8_hvt ad=0.2125 pd=1.425 as=0.165 ps=1.33 w=1 l=0.15
X4 a_253_297# A1 VPWR VPB sky130_fd_pr__pfet_01v8_hvt ad=0.135 pd=1.27 as=0.195 ps=1.39 w=1 l=0.15
X5 VPWR B1 a_103_199# VPB sky130_fd_pr__pfet_01v8_hvt ad=0.345 pd=2.69 as=0.2125 ps=1.425 w=1 l=0.15
X6 VGND a_103_199# X VNB sky130_fd_pr__nfet_01v8 ad=0.12675 pd=1.04 as=0.234 ps=2.02 w=0.65 l=0.15
X7 a_253_47# A1 VGND VNB sky130_fd_pr__nfet_01v8 ad=0.08775 pd=0.92 as=0.12675 ps=1.04 w=0.65 l=0.15
X8 a_253_47# A3 VGND VNB sky130_fd_pr__nfet_01v8 ad=0.10725 pd=0.98 as=0.10725 ps=0.98 w=0.65 l=0.15
X9 VGND A2 a_253_47# VNB sky130_fd_pr__nfet_01v8 ad=0.10725 pd=0.98 as=0.08775 ps=0.92 w=0.65 l=0.15
.ends

.subckt sky130_fd_sc_hd__nand3b_1 VPB VNB VGND VPWR Y B C A_N
X0 Y a_53_93# VPWR VPB sky130_fd_pr__pfet_01v8_hvt ad=0.28 pd=2.56 as=0.1925 ps=1.385 w=1 l=0.15
X1 a_232_47# C VGND VNB sky130_fd_pr__nfet_01v8 ad=0.08775 pd=0.92 as=0.10025 ps=0.985 w=0.65 l=0.15
X2 VPWR B Y VPB sky130_fd_pr__pfet_01v8_hvt ad=0.1925 pd=1.385 as=0.135 ps=1.27 w=1 l=0.15
X3 VPWR A_N a_53_93# VPB sky130_fd_pr__pfet_01v8_hvt ad=0.14575 pd=1.335 as=0.1092 ps=1.36 w=0.42 l=0.15
X4 VGND A_N a_53_93# VNB sky130_fd_pr__nfet_01v8 ad=0.10025 pd=0.985 as=0.1092 ps=1.36 w=0.42 l=0.15
X5 a_316_47# B a_232_47# VNB sky130_fd_pr__nfet_01v8 ad=0.12513 pd=1.035 as=0.08775 ps=0.92 w=0.65 l=0.15
X6 Y a_53_93# a_316_47# VNB sky130_fd_pr__nfet_01v8 ad=0.182 pd=1.86 as=0.12513 ps=1.035 w=0.65 l=0.15
X7 Y C VPWR VPB sky130_fd_pr__pfet_01v8_hvt ad=0.135 pd=1.27 as=0.14575 ps=1.335 w=1 l=0.15
.ends

.subckt sky130_fd_sc_hd__o2bb2ai_1 VPB VNB VGND VPWR B1 B2 Y A2_N A1_N
X0 VPWR A2_N a_112_297# VPB sky130_fd_pr__pfet_01v8_hvt ad=0.42 pd=1.84 as=0.135 ps=1.27 w=1 l=0.15
X1 Y a_112_297# VPWR VPB sky130_fd_pr__pfet_01v8_hvt ad=0.135 pd=1.27 as=0.42 ps=1.84 w=1 l=0.15
X2 VGND B2 a_394_47# VNB sky130_fd_pr__nfet_01v8 ad=0.08775 pd=0.92 as=0.08775 ps=0.92 w=0.65 l=0.15
X3 a_112_297# A2_N a_112_47# VNB sky130_fd_pr__nfet_01v8 ad=0.2405 pd=2.04 as=0.06825 ps=0.86 w=0.65 l=0.15
X4 a_112_47# A1_N VGND VNB sky130_fd_pr__nfet_01v8 ad=0.06825 pd=0.86 as=0.17875 ps=1.85 w=0.65 l=0.15
X5 a_112_297# A1_N VPWR VPB sky130_fd_pr__pfet_01v8_hvt ad=0.135 pd=1.27 as=0.275 ps=2.55 w=1 l=0.15
X6 VPWR B1 a_478_297# VPB sky130_fd_pr__pfet_01v8_hvt ad=0.275 pd=2.55 as=0.135 ps=1.27 w=1 l=0.15
X7 a_394_47# a_112_297# Y VNB sky130_fd_pr__nfet_01v8 ad=0.08775 pd=0.92 as=0.169 ps=1.82 w=0.65 l=0.15
X8 a_394_47# B1 VGND VNB sky130_fd_pr__nfet_01v8 ad=0.169 pd=1.82 as=0.08775 ps=0.92 w=0.65 l=0.15
X9 a_478_297# B2 Y VPB sky130_fd_pr__pfet_01v8_hvt ad=0.135 pd=1.27 as=0.135 ps=1.27 w=1 l=0.15
.ends

.subckt sky130_fd_sc_hd__dlygate4sd3_1 X A VPB VNB VGND VPWR
X0 VPWR A a_49_47# VPB sky130_fd_pr__pfet_01v8_hvt ad=0.0567 pd=0.69 as=0.1092 ps=1.36 w=0.42 l=0.15
X1 VGND a_285_47# a_391_47# VNB sky130_fd_pr__nfet_01v8 ad=0.097 pd=0.975 as=0.1092 ps=1.36 w=0.42 l=0.5
X2 X a_391_47# VPWR VPB sky130_fd_pr__pfet_01v8_hvt ad=0.26 pd=2.52 as=0.14075 ps=1.325 w=1 l=0.15
X3 VGND A a_49_47# VNB sky130_fd_pr__nfet_01v8 ad=0.0567 pd=0.69 as=0.1092 ps=1.36 w=0.42 l=0.15
X4 VPWR a_285_47# a_391_47# VPB sky130_fd_pr__pfet_01v8_hvt ad=0.14075 pd=1.325 as=0.1092 ps=1.36 w=0.42 l=0.5
X5 a_285_47# a_49_47# VGND VNB sky130_fd_pr__nfet_01v8 ad=0.1092 pd=1.36 as=0.0567 ps=0.69 w=0.42 l=0.5
X6 a_285_47# a_49_47# VPWR VPB sky130_fd_pr__pfet_01v8_hvt ad=0.1092 pd=1.36 as=0.0567 ps=0.69 w=0.42 l=0.5
X7 X a_391_47# VGND VNB sky130_fd_pr__nfet_01v8 ad=0.169 pd=1.82 as=0.097 ps=0.975 w=0.65 l=0.15
.ends

.subckt sky130_fd_sc_hd__clkbuf_2 VGND VPWR A X VPB VNB
X0 VPWR A a_27_47# VPB sky130_fd_pr__pfet_01v8_hvt ad=0.1625 pd=1.325 as=0.265 ps=2.53 w=1 l=0.15
X1 VPWR a_27_47# X VPB sky130_fd_pr__pfet_01v8_hvt ad=0.26 pd=2.52 as=0.135 ps=1.27 w=1 l=0.15
X2 VGND A a_27_47# VNB sky130_fd_pr__nfet_01v8 ad=0.06825 pd=0.745 as=0.1113 ps=1.37 w=0.42 l=0.15
X3 X a_27_47# VPWR VPB sky130_fd_pr__pfet_01v8_hvt ad=0.135 pd=1.27 as=0.1625 ps=1.325 w=1 l=0.15
X4 X a_27_47# VGND VNB sky130_fd_pr__nfet_01v8 ad=0.0567 pd=0.69 as=0.06825 ps=0.745 w=0.42 l=0.15
X5 VGND a_27_47# X VNB sky130_fd_pr__nfet_01v8 ad=0.1092 pd=1.36 as=0.0567 ps=0.69 w=0.42 l=0.15
.ends

.subckt sky130_fd_sc_hd__buf_2 VPWR VGND X A VPB VNB
X0 VPWR a_27_47# X VPB sky130_fd_pr__pfet_01v8_hvt ad=0.265 pd=2.53 as=0.135 ps=1.27 w=1 l=0.15
X1 X a_27_47# VPWR VPB sky130_fd_pr__pfet_01v8_hvt ad=0.135 pd=1.27 as=0.149 ps=1.325 w=1 l=0.15
X2 VPWR A a_27_47# VPB sky130_fd_pr__pfet_01v8_hvt ad=0.149 pd=1.325 as=0.1664 ps=1.8 w=0.64 l=0.15
X3 X a_27_47# VGND VNB sky130_fd_pr__nfet_01v8 ad=0.08775 pd=0.92 as=0.097 ps=0.975 w=0.65 l=0.15
X4 VGND a_27_47# X VNB sky130_fd_pr__nfet_01v8 ad=0.17225 pd=1.83 as=0.08775 ps=0.92 w=0.65 l=0.15
X5 VGND A a_27_47# VNB sky130_fd_pr__nfet_01v8 ad=0.097 pd=0.975 as=0.1092 ps=1.36 w=0.42 l=0.15
.ends

.subckt sky130_fd_sc_hd__o2bb2a_1 VNB VPB VPWR VGND X A1_N A2_N B2 B1
X0 a_206_369# A1_N VPWR VPB sky130_fd_pr__pfet_01v8_hvt ad=0.129 pd=1.18 as=0.14575 ps=1.335 w=0.42 l=0.15
X1 a_206_369# A2_N a_205_47# VNB sky130_fd_pr__nfet_01v8 ad=0.1092 pd=1.36 as=0.06615 ps=0.735 w=0.42 l=0.15
X2 VGND B2 a_489_47# VNB sky130_fd_pr__nfet_01v8 ad=0.0567 pd=0.69 as=0.0567 ps=0.69 w=0.42 l=0.15
X3 a_585_369# B2 a_76_199# VPB sky130_fd_pr__pfet_01v8_hvt ad=0.0441 pd=0.63 as=0.0672 ps=0.74 w=0.42 l=0.15
X4 a_489_47# a_206_369# a_76_199# VNB sky130_fd_pr__nfet_01v8 ad=0.0567 pd=0.69 as=0.1092 ps=1.36 w=0.42 l=0.15
X5 a_489_47# B1 VGND VNB sky130_fd_pr__nfet_01v8 ad=0.1092 pd=1.36 as=0.0567 ps=0.69 w=0.42 l=0.15
X6 VPWR A2_N a_206_369# VPB sky130_fd_pr__pfet_01v8_hvt ad=0.20925 pd=1.345 as=0.129 ps=1.18 w=0.42 l=0.15
X7 a_76_199# a_206_369# VPWR VPB sky130_fd_pr__pfet_01v8_hvt ad=0.0672 pd=0.74 as=0.20925 ps=1.345 w=0.42 l=0.15
X8 a_205_47# A1_N VGND VNB sky130_fd_pr__nfet_01v8 ad=0.06615 pd=0.735 as=0.09862 ps=0.98 w=0.42 l=0.15
X9 VPWR a_76_199# X VPB sky130_fd_pr__pfet_01v8_hvt ad=0.14575 pd=1.335 as=0.26 ps=2.52 w=1 l=0.15
X10 VPWR B1 a_585_369# VPB sky130_fd_pr__pfet_01v8_hvt ad=0.1092 pd=1.36 as=0.0441 ps=0.63 w=0.42 l=0.15
X11 VGND a_76_199# X VNB sky130_fd_pr__nfet_01v8 ad=0.09862 pd=0.98 as=0.169 ps=1.82 w=0.65 l=0.15
.ends

.subckt sky130_fd_sc_hd__o211a_1 VNB VPB VGND VPWR X A1 A2 B1 C1
X0 VGND A1 a_215_47# VNB sky130_fd_pr__nfet_01v8 ad=0.10563 pd=0.975 as=0.169 ps=1.82 w=0.65 l=0.15
X1 a_510_47# B1 a_215_47# VNB sky130_fd_pr__nfet_01v8 ad=0.11375 pd=1 as=0.143 ps=1.09 w=0.65 l=0.15
X2 a_79_21# C1 VPWR VPB sky130_fd_pr__pfet_01v8_hvt ad=0.3 pd=2.6 as=0.175 ps=1.35 w=1 l=0.15
X3 VPWR B1 a_79_21# VPB sky130_fd_pr__pfet_01v8_hvt ad=0.175 pd=1.35 as=0.22 ps=1.44 w=1 l=0.15
X4 a_79_21# A2 a_297_297# VPB sky130_fd_pr__pfet_01v8_hvt ad=0.22 pd=1.44 as=0.1625 ps=1.325 w=1 l=0.15
X5 a_297_297# A1 VPWR VPB sky130_fd_pr__pfet_01v8_hvt ad=0.1625 pd=1.325 as=0.26 ps=2.52 w=1 l=0.15
X6 a_79_21# C1 a_510_47# VNB sky130_fd_pr__nfet_01v8 ad=0.195 pd=1.9 as=0.11375 ps=1 w=0.65 l=0.15
X7 VPWR a_79_21# X VPB sky130_fd_pr__pfet_01v8_hvt ad=0.26 pd=2.52 as=0.26 ps=2.52 w=1 l=0.15
X8 VGND a_79_21# X VNB sky130_fd_pr__nfet_01v8 ad=0.169 pd=1.82 as=0.169 ps=1.82 w=0.65 l=0.15
X9 a_215_47# A2 VGND VNB sky130_fd_pr__nfet_01v8 ad=0.143 pd=1.09 as=0.10563 ps=0.975 w=0.65 l=0.15
.ends

.subckt mac8 A[0] A[1] A[2] A[3] A[4] A[5] A[6] A[7] B[0] B[1] B[2] B[3] B[4] B[5]
+ B[6] B[7] VGND VPWR Y[0] Y[10] Y[11] Y[12] Y[13] Y[14] Y[15] Y[16] Y[17] Y[18] Y[19]
+ Y[1] Y[2] Y[3] Y[4] Y[5] Y[6] Y[7] Y[8] Y[9] clk enable reset
XFILLER_22_144 VGND VPWR VPWR VGND sky130_ef_sc_hd__decap_12
XFILLER_3_89 VPWR VGND VPWR VGND sky130_fd_sc_hd__decap_3
X_0985_ VPWR VGND VGND VPWR _1094_/Q _0986_/B Y[11] sky130_fd_sc_hd__nand2_1
Xclkbuf_0_g_fast.genblk1.g_f2.g_cg.u_cg_p.gclk VGND VPWR g_fast.genblk1.g_f2.g_cg.u_cg_p.u_icg/GCLK
+ clkbuf_0_g_fast.genblk1.g_f2.g_cg.u_cg_p.gclk/X VPWR VGND sky130_fd_sc_hd__clkbuf_4
XFILLER_10_147 VGND VPWR VPWR VGND sky130_ef_sc_hd__decap_12
X_0770_ VPWR VGND VPWR VGND A[6] A[7] B[3] _0771_/A B[4] sky130_fd_sc_hd__a22o_1
X_0968_ VPWR VGND VGND VPWR _0968_/A _0979_/A _0968_/B sky130_fd_sc_hd__nand2_1
XFILLER_23_53 VPWR VGND VPWR VGND sky130_fd_sc_hd__decap_3
X_0899_ VPWR VGND VGND VPWR _0899_/A _0900_/B _0899_/B sky130_fd_sc_hd__nand2_1
X_0753_ VGND VPWR _0753_/B _0754_/A _0792_/A VPWR VGND sky130_fd_sc_hd__xnor2_1
X_0822_ VGND VPWR VGND VPWR _0822_/A _0823_/B _0806_/B sky130_fd_sc_hd__or2b_1
XFILLER_9_99 VPWR VGND VPWR VGND sky130_fd_sc_hd__decap_6
X_0684_ VPWR VGND VGND VPWR _0684_/A _0685_/B _0690_/A sky130_fd_sc_hd__nand2_1
XFILLER_2_132 VPWR VGND VPWR VGND sky130_fd_sc_hd__decap_8
XFILLER_9_44 VPWR VGND VPWR VGND sky130_fd_sc_hd__decap_6
X_1098_ _1098_/Q _1102_/CLK _1098_/D VPWR VGND VPWR VGND sky130_fd_sc_hd__dfxtp_1
X_1021_ VPWR VGND VGND VPWR _1021_/A _1021_/Y _1045_/A sky130_fd_sc_hd__nand2_1
X_0805_ VPWR VGND VPWR VGND A[5] B[6] _0803_/X _0806_/B sky130_fd_sc_hd__a21o_1
X_0736_ VPWR VGND _0746_/B _0736_/B _0736_/A VPWR VGND sky130_fd_sc_hd__and2_1
X_0667_ VGND VPWR VGND VPWR _0667_/A _0668_/B _0610_/B sky130_fd_sc_hd__or2b_1
X_0598_ VGND VPWR _0599_/A B[6] _0598_/A _0853_/B VPWR VGND sky130_fd_sc_hd__and3_1
XFILLER_20_54 VPWR VGND VPWR VGND sky130_fd_sc_hd__decap_3
X_1004_ VPWR VGND VGND VPWR _1004_/A _1032_/A _1004_/B sky130_fd_sc_hd__nand2_1
XPHY_EDGE_ROW_16_Left_48 VPWR VGND VPWR VGND sky130_fd_sc_hd__decap_3
XFILLER_13_3 VPWR VGND VPWR VGND sky130_fd_sc_hd__decap_3
XFILLER_6_45 VPWR VGND VPWR VGND sky130_fd_sc_hd__decap_6
XFILLER_6_67 VGND VPWR VPWR VGND sky130_fd_sc_hd__decap_4
XFILLER_6_89 VPWR VGND VPWR VGND sky130_fd_sc_hd__decap_8
XFILLER_31_53 VPWR VGND VPWR VGND sky130_fd_sc_hd__decap_3
XFILLER_15_32 VGND VPWR VPWR VGND sky130_fd_sc_hd__decap_4
X_0719_ VPWR VGND VGND VPWR _0721_/B _0720_/B _0721_/A sky130_fd_sc_hd__nand2_1
XFILLER_31_97 VPWR VGND VPWR VGND sky130_fd_sc_hd__decap_6
XFILLER_3_57 VPWR VGND VPWR VGND sky130_fd_sc_hd__decap_8
X_0984_ VPWR VGND VGND VPWR _0986_/A _1094_/Q Y[11] sky130_fd_sc_hd__or2_1
XPHY_EDGE_ROW_19_Left_51 VPWR VGND VPWR VGND sky130_fd_sc_hd__decap_3
XPHY_EDGE_ROW_21_Right_21 VPWR VGND VPWR VGND sky130_fd_sc_hd__decap_3
X_0967_ VPWR VGND VGND VPWR _0969_/A _0968_/B _0968_/A sky130_fd_sc_hd__or2_1
XPHY_EDGE_ROW_12_Right_12 VPWR VGND VPWR VGND sky130_fd_sc_hd__decap_3
XPHY_EDGE_ROW_4_Left_36 VPWR VGND VPWR VGND sky130_fd_sc_hd__decap_3
X_0898_ VPWR VGND VGND VPWR _0914_/B _0899_/B _0899_/A sky130_fd_sc_hd__or2_1
XPHY_EDGE_ROW_30_Right_30 VPWR VGND VPWR VGND sky130_fd_sc_hd__decap_3
X_0821_ VGND VPWR VPWR VGND _0821_/A _1094_/D sky130_fd_sc_hd__clkinv_2
X_0752_ VPWR VGND VGND VPWR _0793_/A _0753_/B _0752_/B sky130_fd_sc_hd__nand2_1
XFILLER_23_65 VPWR VGND VPWR VGND sky130_fd_sc_hd__decap_3
XFILLER_0_47 VPWR VGND VPWR VGND sky130_fd_sc_hd__decap_8
X_1097_ _1097_/Q _1108_/CLK _1097_/D VPWR VGND VPWR VGND sky130_fd_sc_hd__dfxtp_1
X_0683_ VPWR VGND VGND VPWR _0683_/A _0690_/A _0683_/B sky130_fd_sc_hd__nand2_1
X_1020_ VPWR VGND VGND VPWR _1020_/X _1045_/A _1021_/A sky130_fd_sc_hd__or2_1
X_0804_ VGND VPWR VPWR VGND _0804_/B _0803_/X _0804_/A _0823_/A sky130_fd_sc_hd__or3b_1
X_0666_ VPWR VGND VPWR VGND _0670_/B _0666_/A sky130_fd_sc_hd__inv_2
X_0735_ VPWR VGND VGND VPWR _0735_/A _0764_/B _0735_/B sky130_fd_sc_hd__nand2_1
X_0597_ VPWR VGND VGND VPWR _0597_/A _0598_/A _0597_/B sky130_fd_sc_hd__nand2_1
XFILLER_20_22 VPWR VGND VPWR VGND sky130_fd_sc_hd__decap_6
X_1003_ VPWR VGND VGND VPWR _1017_/A _1004_/A _1003_/B sky130_fd_sc_hd__nand2_1
X_0718_ VPWR VGND VPWR VGND _0721_/A _0718_/A sky130_fd_sc_hd__inv_2
XPHY_EDGE_ROW_6_Right_6 VPWR VGND VPWR VGND sky130_fd_sc_hd__decap_3
X_0649_ VPWR VGND VGND VPWR B[7] _0650_/A _0853_/B sky130_fd_sc_hd__nand2_1
XFILLER_31_113 VGND VPWR VPWR VGND sky130_ef_sc_hd__decap_12
X_0983_ VPWR VGND VPWR VGND _0972_/B _0989_/B _0972_/A _1103_/Q sky130_fd_sc_hd__a21boi_1
XFILLER_12_56 VGND VPWR VPWR VGND sky130_fd_sc_hd__decap_4
XPHY_EDGE_ROW_20_Left_52 VPWR VGND VPWR VGND sky130_fd_sc_hd__decap_3
X_0897_ VPWR VGND VGND VPWR _0897_/A _0899_/A _0911_/B sky130_fd_sc_hd__nand2_1
X_0966_ VPWR VGND VGND VPWR _0966_/A _0968_/A _0966_/B sky130_fd_sc_hd__nand2_1
XFILLER_23_33 VGND VPWR VPWR VGND sky130_fd_sc_hd__decap_4
XFILLER_0_15 VGND VPWR VPWR VGND sky130_ef_sc_hd__decap_12
XFILLER_3_3 VPWR VGND VPWR VGND sky130_fd_sc_hd__decap_8
XFILLER_9_35 VPWR VGND VPWR VGND sky130_fd_sc_hd__decap_3
X_0820_ VPWR VGND VPWR VGND _0818_/Y _0815_/Y _0819_/X _0821_/A sky130_fd_sc_hd__a21o_1
X_1096_ _1096_/Q _1108_/CLK _1096_/D VPWR VGND VPWR VGND sky130_fd_sc_hd__dfxtp_1
X_0751_ VGND VPWR _0750_/B _0750_/C _0752_/B _0804_/A VPWR VGND sky130_fd_sc_hd__o21ai_1
X_0682_ VPWR VGND VGND VPWR _0684_/A _0683_/B _0683_/A sky130_fd_sc_hd__or2_1
X_0949_ VGND VPWR VGND VPWR _0949_/A _0966_/B _0950_/A sky130_fd_sc_hd__or2b_1
X_0803_ VGND VPWR VGND VPWR _0803_/A _0803_/X _0769_/X sky130_fd_sc_hd__or2b_1
X_0665_ VGND VPWR VPWR VGND _0665_/A _0666_/A _0665_/B sky130_fd_sc_hd__xor2_1
X_0734_ VPWR VGND VPWR VGND _1091_/D _0734_/A sky130_fd_sc_hd__inv_2
X_1079_ VPWR VGND VPWR VGND _1081_/B Y[19] sky130_fd_sc_hd__inv_2
X_0596_ VGND VPWR VGND VPWR _0596_/A _0597_/B _0572_/B sky130_fd_sc_hd__or2b_1
XFILLER_29_76 VGND VPWR VPWR VGND sky130_ef_sc_hd__decap_12
X_1002_ VPWR VGND VGND VPWR _1002_/A _1031_/A _1002_/B sky130_fd_sc_hd__nand2_1
XFILLER_19_185 VGND VPWR VPWR VGND sky130_fd_sc_hd__decap_4
X_0579_ VPWR VGND VPWR VGND _0804_/B _0780_/B _0701_/C _0608_/B _0605_/A sky130_fd_sc_hd__or4_1
X_0717_ VGND VPWR VGND VPWR _0718_/A _0678_/C _0678_/A _0678_/B sky130_fd_sc_hd__a21bo_1
X_0648_ VPWR VGND _0687_/B _0689_/A _0601_/B _0625_/Y _0626_/A VGND VPWR sky130_fd_sc_hd__a31o_1
XFILLER_31_169 VGND VPWR VPWR VGND sky130_fd_sc_hd__decap_4
XFILLER_31_125 VGND VPWR VPWR VGND sky130_ef_sc_hd__decap_12
XFILLER_26_22 VPWR VGND VPWR VGND sky130_fd_sc_hd__decap_6
X_0982_ VGND VPWR _1120_/D _0982_/B _0982_/A _0991_/A VPWR VGND sky130_fd_sc_hd__and3_1
XFILLER_10_106 VPWR VGND VPWR VGND sky130_fd_sc_hd__decap_3
X_0965_ VPWR VGND VPWR VGND _0968_/B _0965_/A sky130_fd_sc_hd__inv_2
X_0896_ VPWR VGND VGND VPWR _1087_/Q _0911_/B Y[4] sky130_fd_sc_hd__nand2_1
X_1095_ _1095_/Q _1108_/CLK _1095_/D VPWR VGND VPWR VGND sky130_fd_sc_hd__dfxtp_1
XFILLER_29_3 VGND VPWR VPWR VGND sky130_ef_sc_hd__decap_12
X_0750_ VPWR VGND VPWR VGND _0750_/B _0750_/C _0804_/A _0793_/A sky130_fd_sc_hd__or3_1
X_0681_ VPWR VGND VPWR VGND _0683_/A _0681_/A sky130_fd_sc_hd__inv_2
XFILLER_18_23 VGND VPWR VPWR VGND sky130_fd_sc_hd__decap_4
X_0879_ VPWR VGND VGND VPWR _0879_/A _0879_/B _0879_/Y _0887_/B sky130_fd_sc_hd__nand3_1
X_0948_ VGND VPWR VGND VPWR _0950_/A _1100_/Q _0933_/A _0933_/B sky130_fd_sc_hd__a21bo_1
X_0802_ VPWR VGND VGND VPWR B[7] _0822_/A A[4] sky130_fd_sc_hd__nand2_1
X_1078_ VPWR VGND VPWR VGND _1081_/C _1078_/A sky130_fd_sc_hd__inv_2
X_0664_ VGND VPWR VGND VPWR _0664_/A _0665_/B _0663_/Y sky130_fd_sc_hd__or2b_1
X_0733_ VPWR VGND VPWR VGND _0844_/A _0728_/Y _0731_/Y _0734_/A _0728_/B sky130_fd_sc_hd__a22o_1
X_0595_ VPWR VGND VGND VPWR _0592_/A _0591_/A _0590_/Y _0629_/B sky130_fd_sc_hd__o21a_1
X_1001_ VPWR VGND VGND VPWR _1001_/A _1002_/B _1001_/B sky130_fd_sc_hd__nand2_1
X_0578_ VPWR VGND VPWR VGND _0780_/B A[4] sky130_fd_sc_hd__inv_2
X_0716_ VGND VPWR _0736_/A _0715_/X _0721_/B _0706_/Y VPWR VGND sky130_fd_sc_hd__o21ai_1
Xclkbuf_1_0__f_g_fast.g_acc_cg.u_cg_a.gclk VGND VPWR clkbuf_0_g_fast.g_acc_cg.u_cg_a.gclk/X
+ clkload0/A VPWR VGND sky130_fd_sc_hd__clkbuf_4
X_0647_ VGND VPWR VPWR VGND _0647_/A _1085_/D sky130_fd_sc_hd__clkinv_2
XFILLER_15_57 VGND VPWR VPWR VGND sky130_fd_sc_hd__decap_4
XFILLER_31_137 VPWR VGND VPWR VGND sky130_fd_sc_hd__decap_3
XFILLER_11_3 VGND VPWR VPWR VGND sky130_ef_sc_hd__decap_12
XFILLER_26_45 VPWR VGND VPWR VGND sky130_fd_sc_hd__decap_3
XFILLER_22_126 VGND VPWR VPWR VGND sky130_ef_sc_hd__decap_12
XFILLER_22_115 VGND VPWR VPWR VGND sky130_fd_sc_hd__decap_4
X_0981_ VPWR VGND VGND VPWR _0981_/A _0991_/A _0981_/B sky130_fd_sc_hd__nand2_1
XFILLER_13_159 VPWR VGND VPWR VGND sky130_fd_sc_hd__decap_6
XFILLER_12_170 VPWR VGND VPWR VGND sky130_fd_sc_hd__decap_3
X_0964_ VPWR VGND VGND VPWR _0979_/B _0965_/A _0964_/B sky130_fd_sc_hd__nand2_1
X_0895_ VPWR VGND VGND VPWR _0897_/A _1087_/Q Y[4] sky130_fd_sc_hd__or2_1
XFILLER_23_57 VPWR VGND VPWR VGND sky130_fd_sc_hd__decap_8
XFILLER_4_92 VGND VPWR VPWR VGND sky130_fd_sc_hd__decap_4
X_0680_ VGND VPWR VGND VPWR _0681_/A _0622_/C _0622_/B _0622_/A sky130_fd_sc_hd__a21bo_1
X_1094_ _1094_/Q _1108_/CLK _1094_/D VPWR VGND VPWR VGND sky130_fd_sc_hd__dfxtp_1
X_0878_ VPWR VGND VPWR VGND _0887_/B _0879_/B _0879_/A _0880_/A sky130_fd_sc_hd__a21oi_1
X_0947_ VGND VPWR VPWR VGND _1101_/Q _0949_/A _0947_/B sky130_fd_sc_hd__xor2_1
Xclkload0 VGND VPWR clkload0/X clkload0/A VPWR VGND sky130_fd_sc_hd__clkbuf_1
X_1077_ VPWR VGND VGND VPWR Y[17] _1078_/A Y[18] sky130_fd_sc_hd__nand2_1
X_0801_ VPWR VGND _0810_/B _0801_/B _0849_/B VPWR VGND sky130_fd_sc_hd__and2_1
X_0663_ VGND VPWR _0608_/B _0660_/A _0663_/Y _0829_/A VPWR VGND sky130_fd_sc_hd__o21ai_1
X_0732_ VPWR VGND _0844_/A _0732_/B _0732_/A VPWR VGND sky130_fd_sc_hd__and2_1
X_0594_ VGND VPWR VPWR VGND _0594_/A _1088_/D sky130_fd_sc_hd__clkinv_2
XFILLER_20_69 VGND VPWR VPWR VGND sky130_fd_sc_hd__decap_4
X_1000_ VPWR VGND VGND VPWR _1002_/A _1001_/B _1001_/A sky130_fd_sc_hd__or2_1
XFILLER_19_143 VGND VPWR VPWR VGND sky130_fd_sc_hd__decap_4
X_0715_ VPWR VGND VPWR VGND _0714_/B _0736_/B _0714_/A _0715_/X sky130_fd_sc_hd__a21o_1
XFILLER_6_38 VGND VPWR VPWR VGND sky130_fd_sc_hd__decap_4
XFILLER_31_57 VGND VPWR VPWR VGND sky130_ef_sc_hd__decap_12
X_1129_ Y[19] _1129_/CLK _1129_/D VPWR VGND VPWR VGND sky130_fd_sc_hd__dfxtp_2
X_0577_ VPWR VGND VPWR VGND _0804_/B A[5] sky130_fd_sc_hd__inv_2
X_0646_ VPWR VGND VGND VPWR _0857_/B _0647_/A _0646_/B sky130_fd_sc_hd__nand2_1
XPHY_EDGE_ROW_28_Right_28 VPWR VGND VPWR VGND sky130_fd_sc_hd__decap_3
XPHY_EDGE_ROW_19_Right_19 VPWR VGND VPWR VGND sky130_fd_sc_hd__decap_3
X_0629_ _0630_/B _0628_/B _0629_/B VGND VPWR VPWR VGND sky130_fd_sc_hd__and2b_1
XFILLER_21_160 VPWR VGND VPWR VGND sky130_fd_sc_hd__decap_8
XFILLER_3_28 VPWR VGND VPWR VGND sky130_fd_sc_hd__decap_3
X_0980_ VPWR VGND VGND VPWR _0982_/A _0981_/B _0981_/A sky130_fd_sc_hd__or2_1
X_0963_ VGND VPWR VGND VPWR _0963_/A _0964_/B _0962_/A sky130_fd_sc_hd__or2b_1
X_0894_ VGND VPWR _1113_/D _0956_/B _0894_/A _0902_/A VPWR VGND sky130_fd_sc_hd__and3_1
XFILLER_5_101 VGND VPWR VPWR VGND sky130_fd_sc_hd__decap_4
XPHY_EDGE_ROW_24_Left_56 VPWR VGND VPWR VGND sky130_fd_sc_hd__decap_3
XFILLER_0_29 VPWR VGND VPWR VGND sky130_fd_sc_hd__decap_8
Xclkbuf_1_1__f_g_fast.g_acc_cg.u_cg_a.gclk VGND VPWR clkbuf_0_g_fast.g_acc_cg.u_cg_a.gclk/X
+ _1129_/CLK VPWR VGND sky130_fd_sc_hd__clkbuf_4
X_1093_ _1093_/Q _1108_/CLK _1093_/D VPWR VGND VPWR VGND sky130_fd_sc_hd__dfxtp_1
X_0877_ VPWR VGND VPWR VGND _0879_/A _0877_/A sky130_fd_sc_hd__inv_2
X_0946_ VPWR VGND VGND VPWR _0946_/A _0947_/B _0946_/B sky130_fd_sc_hd__nand2_1
XFILLER_1_3 VGND VPWR VPWR VGND sky130_ef_sc_hd__decap_12
X_0662_ VPWR VGND VPWR VGND _0829_/A A[7] sky130_fd_sc_hd__inv_2
X_0800_ VPWR VGND VPWR VGND A[6] A[7] B[4] _0801_/B B[5] sky130_fd_sc_hd__a22o_1
X_0593_ VGND VPWR VPWR VGND _0633_/A _0594_/A _0842_/B sky130_fd_sc_hd__xor2_1
X_0731_ VGND VPWR VPWR VGND _0732_/B _0731_/Y sky130_fd_sc_hd__clkinv_2
X_1076_ VPWR VGND VPWR VGND _1075_/Y _1073_/Y _0860_/A _1128_/D sky130_fd_sc_hd__a21oi_1
X_0929_ VPWR VGND VGND VPWR _0929_/A _0940_/A _0929_/B sky130_fd_sc_hd__nand2_1
X_1128_ VGND VPWR VGND VPWR Y[18] _1128_/D _1129_/CLK sky130_fd_sc_hd__dfxtp_4
X_1059_ VPWR VGND VGND VPWR _1059_/X _1062_/A _1070_/A sky130_fd_sc_hd__or2_1
X_0714_ VPWR VGND VGND VPWR _0714_/A _0736_/A _0714_/B sky130_fd_sc_hd__nand2_1
X_0645_ VGND VPWR VGND VPWR _0645_/A _0646_/B _0637_/A sky130_fd_sc_hd__or2b_1
X_0576_ VPWR VGND VGND VPWR B[2] _0604_/A A[3] sky130_fd_sc_hd__nand2_1
XPHY_EDGE_ROW_11_Left_43 VPWR VGND VPWR VGND sky130_fd_sc_hd__decap_3
XFILLER_31_69 VGND VPWR VPWR VGND sky130_ef_sc_hd__decap_12
XFILLER_16_103 VGND VPWR VPWR VGND sky130_fd_sc_hd__decap_4
X_0628_ _1100_/D _0629_/B _0628_/B VGND VPWR VPWR VGND sky130_fd_sc_hd__and2b_1
XFILLER_26_58 VGND VPWR VPWR VGND sky130_ef_sc_hd__decap_12
X_0559_ VPWR VGND VGND VPWR _0559_/A _0560_/B _0559_/B sky130_fd_sc_hd__nand2_1
XFILLER_16_91 VGND VPWR VPWR VGND sky130_ef_sc_hd__decap_12
XFILLER_12_183 VPWR VGND VPWR VGND sky130_fd_sc_hd__decap_6
X_0962_ VGND VPWR VGND VPWR _0962_/A _0979_/B _0963_/A sky130_fd_sc_hd__or2b_1
X_0893_ VPWR VGND VGND VPWR _0893_/A _0902_/A _0893_/B sky130_fd_sc_hd__nand2_1
X_1092_ _1092_/Q _1108_/CLK _1092_/D VPWR VGND VPWR VGND sky130_fd_sc_hd__dfxtp_1
X_0876_ VPWR VGND VGND VPWR _1085_/Q _0887_/B Y[2] sky130_fd_sc_hd__nand2_1
X_0945_ VPWR VGND VGND VPWR _1091_/Q _0946_/B Y[8] sky130_fd_sc_hd__nand2_1
XFILLER_18_15 VGND VPWR VPWR VGND sky130_fd_sc_hd__decap_4
XFILLER_27_3 VPWR VGND VPWR VGND sky130_fd_sc_hd__decap_3
X_0661_ VGND VPWR _0664_/A A[7] _0661_/A _0853_/A VPWR VGND sky130_fd_sc_hd__and3_1
X_0730_ VPWR VGND VGND VPWR _0730_/A _0732_/B _0730_/B sky130_fd_sc_hd__nand2_1
X_0592_ VGND VPWR VPWR VGND _0592_/A _0842_/B _0592_/B sky130_fd_sc_hd__xor2_1
XFILLER_29_36 VGND VPWR VPWR VGND sky130_fd_sc_hd__decap_4
X_1075_ VPWR VGND VGND VPWR _1075_/A Y[17] _1075_/Y _1075_/C sky130_fd_sc_hd__nand3_1
X_0859_ VGND VPWR VPWR VGND _0859_/A _1086_/D sky130_fd_sc_hd__clkinv_2
X_0928_ VPWR VGND VGND VPWR _0930_/A _0929_/B _0929_/A sky130_fd_sc_hd__or2_1
XFILLER_10_93 VPWR VGND VPWR VGND sky130_fd_sc_hd__decap_8
XFILLER_6_18 VPWR VGND VPWR VGND sky130_fd_sc_hd__decap_8
XFILLER_6_29 VPWR VGND VPWR VGND sky130_fd_sc_hd__decap_3
X_1127_ VGND VPWR VGND VPWR Y[17] _1127_/D _1129_/CLK sky130_fd_sc_hd__dfxtp_4
XFILLER_25_137 VGND VPWR VPWR VGND sky130_fd_sc_hd__decap_4
X_1058_ VPWR VGND VGND VPWR _1058_/A _1070_/A _1058_/B sky130_fd_sc_hd__nand2_1
X_0713_ VPWR VGND VGND VPWR _0714_/B _0713_/A _0713_/B sky130_fd_sc_hd__or2_1
X_0575_ VGND VPWR VPWR VGND A[2] B[2] _0537_/X _0585_/B _0538_/A sky130_fd_sc_hd__a31oi_1
X_0644_ VGND VPWR VPWR VGND _0644_/A _1087_/D sky130_fd_sc_hd__clkinv_2
XFILLER_31_107 VGND VPWR VPWR VGND sky130_fd_sc_hd__decap_4
XFILLER_31_15 VPWR VGND VPWR VGND sky130_fd_sc_hd__decap_8
XFILLER_16_137 VPWR VGND VPWR VGND sky130_fd_sc_hd__decap_3
XPHY_EDGE_ROW_1_Right_1 VPWR VGND VPWR VGND sky130_fd_sc_hd__decap_3
XFILLER_26_37 VPWR VGND VPWR VGND sky130_fd_sc_hd__decap_8
X_0558_ VGND VPWR VGND VPWR _0565_/B _0634_/B _0635_/A _0634_/A sky130_fd_sc_hd__a21bo_1
X_0627_ VGND VPWR VPWR VGND _0627_/A _0628_/B _0627_/B sky130_fd_sc_hd__xor2_1
XFILLER_12_39 VGND VPWR VPWR VGND sky130_fd_sc_hd__decap_4
X_0961_ VGND VPWR VGND VPWR _0963_/A _1101_/Q _0946_/A _0946_/B sky130_fd_sc_hd__a21bo_1
X_0892_ VPWR VGND VGND VPWR _0894_/A _0893_/B _0893_/A sky130_fd_sc_hd__or2_1
XFILLER_2_106 VPWR VGND VPWR VGND sky130_fd_sc_hd__decap_3
X_1091_ _1091_/Q _1102_/CLK _1091_/D VPWR VGND VPWR VGND sky130_fd_sc_hd__dfxtp_1
X_0944_ VPWR VGND VGND VPWR _0946_/A _1091_/Q Y[8] sky130_fd_sc_hd__or2_1
X_0875_ VPWR VGND VGND VPWR _0875_/A _0879_/B _0875_/B sky130_fd_sc_hd__nand2_1
X_0660_ VPWR VGND VPWR VGND _0661_/A _0660_/A sky130_fd_sc_hd__inv_2
X_0591_ VGND VPWR VGND VPWR _0591_/A _0592_/B _0590_/Y sky130_fd_sc_hd__or2b_1
XFILLER_29_15 VGND VPWR VPWR VGND sky130_ef_sc_hd__decap_12
X_0789_ VPWR VGND VGND VPWR _0789_/A _0791_/A _0789_/B sky130_fd_sc_hd__nand2_1
X_1074_ VGND VPWR VPWR VGND Y[18] _1075_/C sky130_fd_sc_hd__clkinv_2
XFILLER_20_39 VGND VPWR VPWR VGND sky130_fd_sc_hd__decap_4
X_0858_ VPWR VGND VGND VPWR _0858_/A _0859_/A _0858_/B sky130_fd_sc_hd__nand2_1
X_0927_ VPWR VGND VGND VPWR _0927_/A _0929_/A _0927_/B sky130_fd_sc_hd__nand2_1
XFILLER_28_124 VGND VPWR VPWR VGND sky130_ef_sc_hd__decap_12
XFILLER_19_102 VPWR VGND VPWR VGND sky130_fd_sc_hd__decap_8
X_0712_ VPWR VGND VPWR VGND _0714_/A _0712_/A sky130_fd_sc_hd__inv_2
X_1126_ Y[16] _1129_/CLK _1126_/D VPWR VGND VPWR VGND sky130_fd_sc_hd__dfxtp_2
X_0574_ VPWR VGND VPWR VGND _0587_/A _0574_/A sky130_fd_sc_hd__inv_2
X_0643_ VPWR VGND VGND VPWR _0644_/A _1098_/D _0643_/B sky130_fd_sc_hd__or2_1
X_1057_ VPWR VGND VGND VPWR _1030_/A _1062_/B _1044_/B _1058_/B sky130_fd_sc_hd__o21a_1
Xclkbuf_0_clk VGND VPWR clk clkbuf_0_clk/X VPWR VGND sky130_fd_sc_hd__clkbuf_4
XPHY_EDGE_ROW_24_Right_24 VPWR VGND VPWR VGND sky130_fd_sc_hd__decap_3
X_1109_ _1109_/Q _1109_/CLK _1109_/D VPWR VGND VPWR VGND sky130_fd_sc_hd__dfxtp_1
XPHY_EDGE_ROW_15_Right_15 VPWR VGND VPWR VGND sky130_fd_sc_hd__decap_3
X_0557_ VPWR VGND VPWR VGND _0701_/C _0654_/B _0695_/B _0608_/B _0634_/A sky130_fd_sc_hd__or4_1
X_0626_ VGND VPWR VGND VPWR _0626_/A _0627_/B _0625_/Y sky130_fd_sc_hd__or2b_1
X_0609_ VPWR VGND VPWR VGND A[5] A[6] _0853_/A _0610_/B _0659_/B sky130_fd_sc_hd__a22o_1
X_0960_ VGND VPWR VPWR VGND _1102_/Q _0962_/A _0960_/B sky130_fd_sc_hd__xor2_1
X_0891_ VGND VPWR _0880_/A _0879_/Y _0893_/A _0882_/B VPWR VGND sky130_fd_sc_hd__o21ai_1
XFILLER_4_181 VPWR VGND VPWR VGND sky130_fd_sc_hd__decap_8
X_1090_ _1090_/Q _1102_/CLK _1090_/D VPWR VGND VPWR VGND sky130_fd_sc_hd__dfxtp_1
X_0874_ VGND VPWR VPWR VGND Y[2] _0875_/B sky130_fd_sc_hd__clkinv_2
X_0943_ VGND VPWR _1117_/D _0956_/B _0943_/A _0953_/A VPWR VGND sky130_fd_sc_hd__and3_1
X_1073_ VPWR VGND VGND VPWR _1073_/A _1073_/Y Y[18] sky130_fd_sc_hd__nand2_1
X_0857_ VPWR VGND VGND VPWR _0857_/A _0858_/B _0857_/B sky130_fd_sc_hd__nand2_1
X_0926_ VPWR VGND VPWR VGND _0929_/B _0926_/A sky130_fd_sc_hd__inv_2
XFILLER_1_97 VPWR VGND VPWR VGND sky130_fd_sc_hd__decap_8
X_0590_ VPWR VGND VGND VPWR _0590_/A _0590_/Y _0590_/B sky130_fd_sc_hd__nand2_1
X_0788_ VPWR VGND VPWR VGND _0791_/B _0788_/A sky130_fd_sc_hd__inv_2
X_0711_ VGND VPWR _0711_/B _0712_/A _0711_/A VPWR VGND sky130_fd_sc_hd__xnor2_1
X_0573_ VGND VPWR _0573_/B _0574_/A _0596_/A VPWR VGND sky130_fd_sc_hd__xnor2_1
Xclkbuf_regs_0_clk VGND VPWR clk delaybuf_0_clk/A VPWR VGND sky130_fd_sc_hd__clkbuf_4
X_0642_ VPWR VGND _0643_/B _0642_/B _0858_/A VPWR VGND sky130_fd_sc_hd__and2_1
X_1125_ Y[15] _1129_/CLK _1125_/D VPWR VGND VPWR VGND sky130_fd_sc_hd__dfxtp_2
X_1056_ VPWR VGND VGND VPWR _1056_/A _1058_/A _1056_/B sky130_fd_sc_hd__nand2_1
X_0909_ VGND VPWR VPWR VGND _1098_/Q _0911_/A _0909_/B sky130_fd_sc_hd__xor2_1
X_1039_ VPWR VGND VGND VPWR _1108_/Q _1053_/A Y[15] sky130_fd_sc_hd__nand2_1
X_1108_ _1108_/Q _1108_/CLK _1108_/D VPWR VGND VPWR VGND sky130_fd_sc_hd__dfxtp_1
Xg_fast.g_acc_cg.u_cg_a.u_icg VGND VPWR g_fast.g_acc_cg.u_cg_a.u_icg/GCLK _0852_/X
+ clkbuf_1_1__f_clk/X VPWR VGND sky130_fd_sc_hd__dlclkp_1
XPHY_EDGE_ROW_15_Left_47 VPWR VGND VPWR VGND sky130_fd_sc_hd__decap_3
X_0556_ VPWR VGND VPWR VGND _0659_/B _0853_/A A[2] _0634_/B A[1] sky130_fd_sc_hd__a22o_1
X_0625_ VPWR VGND VGND VPWR _0625_/A _0625_/Y _0625_/B sky130_fd_sc_hd__nand2_1
X_0608_ VPWR VGND VPWR VGND _0608_/B _0701_/C _0804_/B _0826_/B _0668_/A sky130_fd_sc_hd__or4_1
X_0539_ VGND VPWR VPWR VGND _0539_/A _0540_/A _0539_/B sky130_fd_sc_hd__xor2_1
X_0890_ VPWR VGND VPWR VGND _0893_/B _0890_/A sky130_fd_sc_hd__inv_2
XFILLER_4_42 VGND VPWR VPWR VGND sky130_ef_sc_hd__decap_12
XPHY_EDGE_ROW_18_Left_50 VPWR VGND VPWR VGND sky130_fd_sc_hd__decap_3
XFILLER_13_95 VPWR VGND VPWR VGND sky130_fd_sc_hd__decap_3
XFILLER_18_29 VGND VPWR VPWR VGND sky130_ef_sc_hd__decap_12
X_0873_ VGND VPWR VPWR VGND _1085_/Q _0875_/A sky130_fd_sc_hd__clkinv_2
X_0942_ VPWR VGND VGND VPWR _0942_/A _0953_/A _0942_/B sky130_fd_sc_hd__nand2_1
XPHY_EDGE_ROW_3_Left_35 VPWR VGND VPWR VGND sky130_fd_sc_hd__decap_3
X_1072_ VPWR VGND VGND VPWR _1075_/A _1073_/A Y[17] sky130_fd_sc_hd__nand2_1
X_0787_ VPWR VGND VGND VPWR _0788_/A _0787_/A _0787_/B sky130_fd_sc_hd__or2_1
Xg_fast.genblk1.g_f2.g_cg.u_cg_p.u_icg VGND VPWR g_fast.genblk1.g_f2.g_cg.u_cg_p.u_icg/GCLK
+ enable clkbuf_1_0__f_clk/X VPWR VGND sky130_fd_sc_hd__dlclkp_1
X_0856_ _1084_/D _0645_/A _0856_/B VGND VPWR VPWR VGND sky130_fd_sc_hd__and2b_1
X_0925_ VPWR VGND VGND VPWR _0940_/B _0926_/A _0925_/B sky130_fd_sc_hd__nand2_1
X_0710_ VPWR VGND VGND VPWR _0710_/A _0711_/B _0748_/A sky130_fd_sc_hd__nand2_1
X_0641_ VPWR VGND VGND VPWR _0642_/B _0858_/A _1098_/D sky130_fd_sc_hd__nor2_1
XFILLER_31_29 VGND VPWR VPWR VGND sky130_ef_sc_hd__decap_12
X_1055_ VPWR VGND VGND VPWR _1062_/B _1055_/B _1056_/B sky130_fd_sc_hd__nor2_1
XFILLER_25_3 VPWR VGND VPWR VGND sky130_fd_sc_hd__decap_8
X_0839_ VGND VPWR _0839_/B _0840_/B _0850_/B VPWR VGND sky130_fd_sc_hd__xnor2_1
X_1124_ VGND VPWR VGND VPWR Y[14] _1124_/D _1129_/CLK sky130_fd_sc_hd__dfxtp_4
X_0908_ VPWR VGND VGND VPWR _0908_/A _0909_/B _0908_/B sky130_fd_sc_hd__nand2_1
X_0572_ VPWR VGND VGND VPWR _0597_/A _0573_/B _0572_/B sky130_fd_sc_hd__nand2_1
XFILLER_24_151 VGND VPWR VPWR VGND sky130_fd_sc_hd__decap_4
XFILLER_16_129 VPWR VGND VPWR VGND sky130_fd_sc_hd__decap_8
X_0555_ VPWR VGND VPWR VGND _0635_/A _0555_/A sky130_fd_sc_hd__inv_2
X_0624_ VPWR VGND VGND VPWR _0625_/B _0625_/A _0626_/A sky130_fd_sc_hd__nor2_1
XFILLER_26_29 VGND VPWR VPWR VGND sky130_fd_sc_hd__decap_4
X_1038_ VPWR VGND VGND VPWR _1040_/A _1108_/Q Y[15] sky130_fd_sc_hd__or2_1
X_1107_ _1107_/Q _1108_/CLK _1107_/D VPWR VGND VPWR VGND sky130_fd_sc_hd__dfxtp_1
XPHY_EDGE_ROW_5_Right_5 VPWR VGND VPWR VGND sky130_fd_sc_hd__decap_3
X_0607_ VPWR VGND VPWR VGND _0826_/B A[6] sky130_fd_sc_hd__inv_2
X_0538_ VGND VPWR VGND VPWR _0538_/A _0539_/B _0537_/X sky130_fd_sc_hd__or2b_1
XFILLER_7_180 VPWR VGND VPWR VGND sky130_fd_sc_hd__decap_8
XFILLER_27_50 VPWR VGND VPWR VGND sky130_fd_sc_hd__decap_6
XFILLER_4_54 VPWR VGND VPWR VGND sky130_fd_sc_hd__decap_6
XFILLER_4_76 VPWR VGND VPWR VGND sky130_fd_sc_hd__decap_8
XFILLER_4_150 VGND VPWR VPWR VGND sky130_ef_sc_hd__decap_12
X_0872_ VGND VPWR _1111_/D _0882_/B _0872_/A _0956_/B VPWR VGND sky130_fd_sc_hd__and3_1
X_0941_ VPWR VGND VGND VPWR _0943_/A _0942_/B _0942_/A sky130_fd_sc_hd__or2_1
X_1071_ VPWR VGND VGND VPWR _1071_/A _1075_/A _1071_/B sky130_fd_sc_hd__nand2_1
XFILLER_28_105 VGND VPWR VPWR VGND sky130_ef_sc_hd__decap_12
X_0786_ VGND VPWR _0787_/B _0786_/B _0786_/A _0786_/C VPWR VGND sky130_fd_sc_hd__and3_1
X_0855_ VPWR VGND VPWR VGND B[1] B[0] A[1] _0856_/B A[0] sky130_fd_sc_hd__a22o_1
X_0924_ VGND VPWR VGND VPWR _0924_/A _0925_/B _0923_/A sky130_fd_sc_hd__or2b_1
XFILLER_19_84 VPWR VGND VPWR VGND sky130_fd_sc_hd__decap_3
X_1123_ VGND VPWR VGND VPWR Y[13] _1123_/D _1129_/CLK sky130_fd_sc_hd__dfxtp_4
X_1054_ VPWR VGND VGND VPWR _1071_/B _1062_/A _1070_/B sky130_fd_sc_hd__nand2_1
XFILLER_18_3 VGND VPWR VPWR VGND sky130_ef_sc_hd__decap_12
X_0571_ VPWR VGND VPWR VGND B[4] A[2] B[3] _0572_/B A[1] sky130_fd_sc_hd__a22o_1
X_0640_ VPWR VGND VGND VPWR _0858_/A _0857_/B _0857_/A sky130_fd_sc_hd__or2_1
X_0907_ VPWR VGND VGND VPWR _1088_/Q _0908_/B Y[5] sky130_fd_sc_hd__nand2_1
XFILLER_24_141 VPWR VGND VPWR VGND sky130_fd_sc_hd__decap_6
X_0838_ _0850_/B _1108_/D _0838_/B VGND VPWR VPWR VGND sky130_fd_sc_hd__and2b_1
X_0769_ VPWR VGND VPWR VGND _0826_/B _0799_/C _0769_/C _0829_/A _0769_/X sky130_fd_sc_hd__or4_1
X_0554_ VPWR VGND VGND VPWR B[2] _0555_/A _0853_/B sky130_fd_sc_hd__nand2_1
X_0623_ VPWR VGND VGND VPWR _0625_/A _0623_/A _0623_/B sky130_fd_sc_hd__or2_1
X_1106_ _1106_/Q _1108_/CLK _1106_/D VPWR VGND VPWR VGND sky130_fd_sc_hd__dfxtp_1
X_1037_ VPWR VGND VPWR VGND _1036_/Y _1035_/X _0860_/A _1124_/D sky130_fd_sc_hd__a21oi_1
XPHY_EDGE_ROW_20_Right_20 VPWR VGND VPWR VGND sky130_fd_sc_hd__decap_3
XFILLER_16_85 VPWR VGND VPWR VGND sky130_fd_sc_hd__decap_3
XPHY_EDGE_ROW_11_Right_11 VPWR VGND VPWR VGND sky130_fd_sc_hd__decap_3
X_0606_ VPWR VGND VGND VPWR A[4] _0667_/A B[2] sky130_fd_sc_hd__nand2_1
X_0537_ VPWR VGND VPWR VGND _0659_/B _0853_/A A[4] _0537_/X A[3] sky130_fd_sc_hd__a22o_1
XFILLER_13_86 VPWR VGND VPWR VGND sky130_fd_sc_hd__decap_3
XFILLER_13_53 VPWR VGND VPWR VGND sky130_fd_sc_hd__decap_3
X_0871_ VPWR VGND VGND VPWR _0871_/A _0871_/B _0882_/B _0877_/A sky130_fd_sc_hd__nand3_1
X_0940_ VPWR VGND VGND VPWR _0940_/A _0942_/A _0940_/B sky130_fd_sc_hd__nand2_1
XFILLER_24_85 VGND VPWR VPWR VGND sky130_ef_sc_hd__decap_12
XFILLER_28_117 VGND VPWR VPWR VGND sky130_fd_sc_hd__decap_4
X_0785_ VPWR VGND VPWR VGND _0786_/C _0786_/B _0786_/A _0787_/A sky130_fd_sc_hd__a21oi_1
X_1070_ VPWR VGND VGND VPWR _1070_/A _1071_/A _1070_/B sky130_fd_sc_hd__nand2_1
X_0854_ VGND VPWR VPWR VGND _0854_/A _1083_/D sky130_fd_sc_hd__clkinv_2
X_0923_ VGND VPWR VGND VPWR _0923_/A _0940_/B _0924_/A sky130_fd_sc_hd__or2b_1
XFILLER_19_41 VPWR VGND VPWR VGND sky130_fd_sc_hd__decap_3
XFILLER_10_65 VGND VPWR VPWR VGND sky130_ef_sc_hd__decap_12
X_1122_ VGND VPWR VGND VPWR Y[12] _1122_/D _1129_/CLK sky130_fd_sc_hd__dfxtp_4
X_1053_ VPWR VGND VGND VPWR _1053_/A _1070_/B _1053_/B sky130_fd_sc_hd__nand2_1
X_0570_ VPWR VGND VPWR VGND _0769_/C _0654_/B _0799_/C _0695_/B _0597_/A sky130_fd_sc_hd__or4_1
X_0837_ VPWR VGND VPWR VGND B[7] A[7] B[6] _0838_/B A[6] sky130_fd_sc_hd__a22o_1
X_0768_ VGND VPWR VPWR VGND _0768_/A _1092_/D sky130_fd_sc_hd__clkinv_2
X_0699_ VPWR VGND VPWR VGND _0720_/A _0699_/A sky130_fd_sc_hd__inv_2
X_0906_ VPWR VGND VGND VPWR _0908_/A _1088_/Q Y[5] sky130_fd_sc_hd__or2_1
XFILLER_30_3 VGND VPWR VPWR VGND sky130_ef_sc_hd__decap_12
X_1105_ _1105_/Q _1108_/CLK _1105_/D VPWR VGND VPWR VGND sky130_fd_sc_hd__dfxtp_1
X_1036_ VPWR VGND VGND VPWR _1056_/A _1036_/Y _1055_/B sky130_fd_sc_hd__nand2_1
X_0553_ VGND VPWR VPWR VGND _0553_/A _0632_/B _0553_/B sky130_fd_sc_hd__xor2_1
X_0622_ VGND VPWR _0623_/B _0622_/B _0622_/A _0622_/C VPWR VGND sky130_fd_sc_hd__and3_1
XFILLER_12_101 VGND VPWR VPWR VGND sky130_ef_sc_hd__decap_12
X_0536_ _0538_/A A[4] _0853_/A _0659_/B A[3] VGND VPWR VPWR VGND sky130_fd_sc_hd__and4_1
X_0605_ VPWR VGND _0614_/B _0605_/B _0605_/A VPWR VGND sky130_fd_sc_hd__and2_1
X_1019_ VPWR VGND VGND VPWR _1019_/A _1021_/A _1019_/B sky130_fd_sc_hd__nand2_1
XFILLER_27_96 VGND VPWR VPWR VGND sky130_ef_sc_hd__decap_12
XFILLER_4_141 VPWR VGND VPWR VGND sky130_fd_sc_hd__decap_6
X_0870_ VPWR VGND VPWR VGND _0877_/A _0871_/B _0871_/A _0872_/A sky130_fd_sc_hd__a21o_1
X_0999_ VGND VPWR VPWR VGND _1105_/Q _1001_/A _0999_/B sky130_fd_sc_hd__xor2_1
XFILLER_24_97 VPWR VGND VPWR VGND sky130_fd_sc_hd__decap_8
XFILLER_24_20 VPWR VGND VPWR VGND sky130_fd_sc_hd__decap_8
X_0784_ VPWR VGND VPWR VGND _0786_/A _0784_/A sky130_fd_sc_hd__inv_2
X_0853_ VPWR VGND VGND VPWR _0853_/A _0854_/A _0853_/B sky130_fd_sc_hd__nand2_1
XFILLER_1_57 VPWR VGND VPWR VGND sky130_fd_sc_hd__decap_3
X_0922_ VGND VPWR VGND VPWR _0924_/A _1098_/Q _0908_/A _0908_/B sky130_fd_sc_hd__a21bo_1
XFILLER_19_129 VPWR VGND VPWR VGND sky130_fd_sc_hd__decap_8
XFILLER_19_64 VGND VPWR VPWR VGND sky130_ef_sc_hd__decap_12
XPHY_EDGE_ROW_7_Left_39 VPWR VGND VPWR VGND sky130_fd_sc_hd__decap_3
X_1052_ VPWR VGND VGND VPWR _1071_/B _1053_/B _1053_/A sky130_fd_sc_hd__or2_1
X_1121_ VGND VPWR VGND VPWR Y[11] _1121_/D _1129_/CLK sky130_fd_sc_hd__dfxtp_4
XFILLER_24_132 VPWR VGND VPWR VGND sky130_fd_sc_hd__decap_8
X_0836_ VPWR VGND VPWR VGND _0849_/A _0827_/B _0825_/X _0840_/A sky130_fd_sc_hd__a21oi_1
X_0767_ VPWR VGND VGND VPWR _0767_/A _0768_/A _0767_/B sky130_fd_sc_hd__nand2_1
X_0698_ VGND VPWR _0698_/B _0699_/A _0761_/A VPWR VGND sky130_fd_sc_hd__xnor2_1
X_0905_ VGND VPWR _1114_/D _0956_/B _0905_/A _0914_/A VPWR VGND sky130_fd_sc_hd__and3_1
XFILLER_30_124 VPWR VGND VPWR VGND sky130_fd_sc_hd__decap_3
Xdelaybuf_2_clk VGND VPWR delaybuf_2_clk/A delaybuf_2_clk/X VPWR VGND sky130_fd_sc_hd__clkbuf_4
XFILLER_15_165 VPWR VGND VPWR VGND sky130_fd_sc_hd__decap_3
X_1104_ _1104_/Q _1108_/CLK _1104_/D VPWR VGND VPWR VGND sky130_fd_sc_hd__dfxtp_1
X_1035_ VPWR VGND VGND VPWR _1035_/X _1055_/B _1056_/A sky130_fd_sc_hd__or2_1
XFILLER_23_3 VGND VPWR VPWR VGND sky130_ef_sc_hd__decap_12
XFILLER_21_113 VGND VPWR VPWR VGND sky130_fd_sc_hd__decap_4
X_0552_ VPWR VGND VGND VPWR _0552_/A _0553_/B _0552_/B sky130_fd_sc_hd__nand2_1
X_0621_ VPWR VGND VPWR VGND _0622_/B _0622_/A _0622_/C _0623_/A sky130_fd_sc_hd__a21oi_1
XFILLER_7_89 VGND VPWR VPWR VGND sky130_ef_sc_hd__decap_12
X_0819_ VGND VPWR _0819_/X _0819_/B _0819_/A _0819_/C VPWR VGND sky130_fd_sc_hd__and3_1
XFILLER_16_76 VPWR VGND VPWR VGND sky130_fd_sc_hd__decap_8
X_0604_ VGND VPWR VGND VPWR _0604_/A _0605_/B _0581_/B sky130_fd_sc_hd__or2b_1
XPHY_EDGE_ROW_9_Right_9 VPWR VGND VPWR VGND sky130_fd_sc_hd__decap_3
X_1018_ VPWR VGND VGND VPWR _1004_/B _1031_/A _1002_/A _1019_/B sky130_fd_sc_hd__o21a_1
X_0535_ VPWR VGND VGND VPWR B[2] _0539_/A A[2] sky130_fd_sc_hd__nand2_1
X_0998_ VPWR VGND VGND VPWR _0998_/A _0999_/B _0998_/B sky130_fd_sc_hd__nand2_1
X_0783_ VGND VPWR _0783_/B _0784_/A _0816_/A VPWR VGND sky130_fd_sc_hd__xnor2_1
XPHY_EDGE_ROW_23_Left_55 VPWR VGND VPWR VGND sky130_fd_sc_hd__decap_3
X_0852_ VPWR VGND VGND VPWR _0852_/X _0860_/A _1109_/Q sky130_fd_sc_hd__or2_1
X_0921_ VGND VPWR VPWR VGND _1099_/Q _0923_/A _0921_/B sky130_fd_sc_hd__xor2_1
X_0835_ VGND VPWR _0835_/B _1095_/D _0835_/A VPWR VGND sky130_fd_sc_hd__xnor2_1
X_1051_ VPWR VGND VPWR VGND _1053_/B Y[16] sky130_fd_sc_hd__inv_2
XFILLER_18_185 VGND VPWR VPWR VGND sky130_fd_sc_hd__decap_4
X_0766_ VPWR VGND VPWR VGND _0845_/B _0763_/A _0763_/B _0767_/B sky130_fd_sc_hd__a21o_1
X_1120_ VGND VPWR VGND VPWR Y[10] _1120_/D clkload0/A sky130_fd_sc_hd__dfxtp_4
X_0697_ VPWR VGND VGND VPWR _0762_/A _0698_/B _0697_/B sky130_fd_sc_hd__nand2_1
X_0904_ VPWR VGND VGND VPWR _0904_/A _0914_/A _0904_/B sky130_fd_sc_hd__nand2_1
XFILLER_24_166 VPWR VGND VPWR VGND sky130_fd_sc_hd__decap_8
XFILLER_30_114 VPWR VGND VPWR VGND sky130_fd_sc_hd__decap_3
X_1034_ VPWR VGND VGND VPWR _1034_/A _1056_/A _1034_/B sky130_fd_sc_hd__nand2_1
X_1103_ _1103_/Q _1108_/CLK _1103_/D VPWR VGND VPWR VGND sky130_fd_sc_hd__dfxtp_1
X_0551_ VPWR VGND VGND VPWR _0551_/A _0552_/B _0551_/B sky130_fd_sc_hd__nand2_1
X_0620_ VPWR VGND VPWR VGND _0622_/C _0620_/A sky130_fd_sc_hd__inv_2
X_0818_ VGND VPWR VPWR VGND _0819_/C _0818_/Y sky130_fd_sc_hd__clkinv_2
X_0749_ VPWR VGND VGND VPWR _0711_/A _0748_/Y _0710_/A _0750_/C sky130_fd_sc_hd__o21a_1
XPHY_EDGE_ROW_10_Left_42 VPWR VGND VPWR VGND sky130_fd_sc_hd__decap_3
XFILLER_8_118 VGND VPWR VPWR VGND sky130_ef_sc_hd__decap_12
X_1017_ VPWR VGND VGND VPWR _1017_/A _1019_/A _1017_/B sky130_fd_sc_hd__nand2_1
X_0534_ VPWR VGND _0553_/A _0534_/B _0592_/A VPWR VGND sky130_fd_sc_hd__and2_1
X_0603_ VPWR VGND VPWR VGND _0625_/B _0603_/A sky130_fd_sc_hd__inv_2
XFILLER_13_78 VPWR VGND VPWR VGND sky130_fd_sc_hd__decap_8
XFILLER_13_45 VPWR VGND VPWR VGND sky130_fd_sc_hd__decap_8
X_0997_ VPWR VGND VGND VPWR _1095_/Q _0998_/B Y[12] sky130_fd_sc_hd__nand2_1
XFILLER_1_15 VGND VPWR VPWR VGND sky130_ef_sc_hd__decap_12
X_0920_ VPWR VGND VGND VPWR _0920_/A _0921_/B _0920_/B sky130_fd_sc_hd__nand2_1
XPHY_EDGE_ROW_27_Right_27 VPWR VGND VPWR VGND sky130_fd_sc_hd__decap_3
X_0782_ VPWR VGND VGND VPWR _0817_/A _0783_/B _0782_/B sky130_fd_sc_hd__nand2_1
X_0851_ VGND VPWR VGND VPWR _1107_/D _0840_/A _0849_/Y _0850_/B _0850_/X sky130_fd_sc_hd__a211o_1
XPHY_EDGE_ROW_18_Right_18 VPWR VGND VPWR VGND sky130_fd_sc_hd__decap_3
XFILLER_27_175 VPWR VGND VPWR VGND sky130_fd_sc_hd__decap_6
XFILLER_27_164 VGND VPWR VPWR VGND sky130_fd_sc_hd__decap_4
XFILLER_19_33 VPWR VGND VPWR VGND sky130_fd_sc_hd__decap_8
X_1050_ VPWR VGND VPWR VGND _1049_/Y _1048_/X _0860_/A _1125_/D sky130_fd_sc_hd__a21oi_1
X_0834_ VPWR VGND VGND VPWR _0834_/A _0835_/B _0834_/B sky130_fd_sc_hd__nand2_1
X_0765_ VGND VPWR VGND VPWR _0845_/A _0767_/A _0845_/B sky130_fd_sc_hd__or2b_1
X_0696_ VGND VPWR _0695_/B _0695_/C _0697_/B _0804_/A VPWR VGND sky130_fd_sc_hd__o21ai_1
X_0903_ VPWR VGND VGND VPWR _0905_/A _0904_/B _0904_/A sky130_fd_sc_hd__or2_1
XFILLER_15_123 VPWR VGND VPWR VGND sky130_fd_sc_hd__decap_6
XFILLER_15_101 VGND VPWR VPWR VGND sky130_fd_sc_hd__decap_4
X_0550_ VPWR VGND VGND VPWR _0552_/A _0551_/B _0551_/A sky130_fd_sc_hd__or2_1
X_1102_ _1102_/Q _1102_/CLK _1102_/D VPWR VGND VPWR VGND sky130_fd_sc_hd__dfxtp_1
XFILLER_7_14 VGND VPWR VPWR VGND sky130_ef_sc_hd__decap_12
X_1033_ VPWR VGND VGND VPWR _1002_/A _1045_/A _1015_/A _1034_/B sky130_fd_sc_hd__o21a_1
X_0817_ VPWR VGND VGND VPWR _0817_/A _0819_/C _0817_/B sky130_fd_sc_hd__nand2_1
X_0748_ VGND VPWR VPWR VGND _0748_/A _0748_/Y sky130_fd_sc_hd__clkinv_2
X_0679_ VPWR VGND VGND VPWR _0683_/B _0679_/A _0679_/B sky130_fd_sc_hd__or2_1
XFILLER_12_148 VPWR VGND VPWR VGND sky130_fd_sc_hd__decap_3
XPHY_EDGE_ROW_0_Right_0 VPWR VGND VPWR VGND sky130_fd_sc_hd__decap_3
X_1016_ VPWR VGND VGND VPWR _1016_/A _1031_/A _1017_/B sky130_fd_sc_hd__nor2_1
X_0533_ VPWR VGND VPWR VGND B[4] B[3] A[1] _0534_/B _0853_/B sky130_fd_sc_hd__a22o_1
X_0602_ VGND VPWR VGND VPWR _0603_/A _0586_/B _0587_/A _0586_/A sky130_fd_sc_hd__a21bo_1
X_0996_ VPWR VGND VGND VPWR _0998_/A _1095_/Q Y[12] sky130_fd_sc_hd__or2_1
XFILLER_24_78 VPWR VGND VPWR VGND sky130_fd_sc_hd__decap_6
XFILLER_1_27 VGND VPWR VPWR VGND sky130_fd_sc_hd__decap_4
XFILLER_6_3 VPWR VGND VPWR VGND sky130_fd_sc_hd__decap_6
X_0781_ VGND VPWR _0780_/B _0780_/C _0782_/B _0804_/A VPWR VGND sky130_fd_sc_hd__o21ai_1
X_0850_ _0850_/X _0839_/B _0850_/B VGND VPWR VPWR VGND sky130_fd_sc_hd__and2b_1
XFILLER_27_187 VPWR VGND VPWR VGND sky130_fd_sc_hd__decap_3
XFILLER_27_154 VPWR VGND VPWR VGND sky130_fd_sc_hd__decap_6
XFILLER_27_121 VPWR VGND VPWR VGND sky130_fd_sc_hd__decap_8
X_0979_ VPWR VGND VGND VPWR _0979_/A _0981_/A _0979_/B sky130_fd_sc_hd__nand2_1
X_0833_ VPWR VGND VGND VPWR _0833_/A _0834_/B _0833_/B sky130_fd_sc_hd__nand2_1
X_0902_ VPWR VGND VGND VPWR _0902_/A _0904_/A _0902_/B sky130_fd_sc_hd__nand2_1
XFILLER_21_57 VGND VPWR VPWR VGND sky130_fd_sc_hd__decap_4
XFILLER_21_46 VGND VPWR VPWR VGND sky130_fd_sc_hd__decap_4
X_0764_ VPWR VGND VGND VPWR _0764_/A _0845_/B _0764_/B sky130_fd_sc_hd__nand2_1
X_0695_ VPWR VGND VPWR VGND _0695_/B _0695_/C _0804_/A _0762_/A sky130_fd_sc_hd__or3_1
XFILLER_7_26 VPWR VGND VPWR VGND sky130_fd_sc_hd__decap_8
X_1032_ VPWR VGND VGND VPWR _1032_/A _1034_/A _1032_/B sky130_fd_sc_hd__nand2_1
X_0816_ VGND VPWR VGND VPWR _0816_/A _0817_/B _0782_/B sky130_fd_sc_hd__or2b_1
X_0747_ VPWR VGND VGND VPWR B[7] _0792_/A A[2] sky130_fd_sc_hd__nand2_1
X_0678_ VGND VPWR _0679_/B _0678_/B _0678_/A _0678_/C VPWR VGND sky130_fd_sc_hd__and3_1
X_1101_ _1101_/Q _1102_/CLK _1101_/D VPWR VGND VPWR VGND sky130_fd_sc_hd__dfxtp_1
X_1015_ VPWR VGND VGND VPWR _1015_/A _1045_/A _1015_/B sky130_fd_sc_hd__nand2_1
XFILLER_21_3 VPWR VGND VPWR VGND sky130_fd_sc_hd__decap_6
X_0532_ VPWR VGND VPWR VGND _0799_/C _0654_/B _0769_/C _0592_/A _0853_/B sky130_fd_sc_hd__or4b_1
X_0601_ VPWR VGND VGND VPWR _0689_/A _0627_/A _0601_/B sky130_fd_sc_hd__nand2_1
X_0995_ VPWR VGND VPWR VGND _0986_/B _1001_/B _0986_/A _1104_/Q sky130_fd_sc_hd__a21boi_1
XFILLER_24_57 VGND VPWR VPWR VGND sky130_ef_sc_hd__decap_12
X_0780_ VPWR VGND VPWR VGND _0780_/B _0780_/C _0804_/A _0817_/A sky130_fd_sc_hd__or3_1
X_0978_ VPWR VGND VPWR VGND _0981_/B _0978_/A sky130_fd_sc_hd__inv_2
XFILLER_10_15 VPWR VGND VPWR VGND sky130_fd_sc_hd__decap_6
XPHY_EDGE_ROW_27_Left_59 VPWR VGND VPWR VGND sky130_fd_sc_hd__decap_3
X_0832_ VPWR VGND VGND VPWR _0834_/A _0833_/B _0833_/A sky130_fd_sc_hd__or2_1
X_0763_ VPWR VGND VGND VPWR _0763_/A _0845_/A _0763_/B sky130_fd_sc_hd__nand2_1
X_0694_ VPWR VGND VGND VPWR _0675_/A _0693_/Y _0674_/A _0695_/C sky130_fd_sc_hd__o21a_1
X_0901_ VPWR VGND VPWR VGND _0904_/B _0901_/A sky130_fd_sc_hd__inv_2
X_0815_ VPWR VGND VGND VPWR _0819_/A _0815_/Y _0819_/B sky130_fd_sc_hd__nand2_1
X_0746_ VPWR VGND VGND VPWR _0746_/A _0756_/A _0746_/B sky130_fd_sc_hd__nand2_1
X_1031_ VPWR VGND VGND VPWR _1031_/A _1045_/A _1032_/B sky130_fd_sc_hd__nor2_1
X_1100_ _1100_/Q _1102_/CLK _1100_/D VPWR VGND VPWR VGND sky130_fd_sc_hd__dfxtp_1
XFILLER_16_36 VGND VPWR VPWR VGND sky130_ef_sc_hd__decap_12
X_0677_ VPWR VGND VPWR VGND _0678_/C _0678_/B _0678_/A _0679_/A sky130_fd_sc_hd__a21oi_1
XFILLER_14_3 VGND VPWR VPWR VGND sky130_fd_sc_hd__decap_4
X_0531_ VPWR VGND VPWR VGND _0654_/B A[1] sky130_fd_sc_hd__inv_2
X_0600_ VPWR VGND VPWR VGND _0853_/B B[6] _0598_/A _0601_/B sky130_fd_sc_hd__a21o_1
X_1014_ VPWR VGND VGND VPWR _1014_/A _1015_/B _1014_/B sky130_fd_sc_hd__nand2_1
XFILLER_27_57 VGND VPWR VPWR VGND sky130_ef_sc_hd__decap_12
XPHY_EDGE_ROW_14_Left_46 VPWR VGND VPWR VGND sky130_fd_sc_hd__decap_3
X_0729_ VPWR VGND VGND VPWR _0729_/A _0730_/B _0729_/B sky130_fd_sc_hd__nand2_1
X_0994_ VPWR VGND VPWR VGND _0993_/Y _0992_/X _0860_/A _1121_/D sky130_fd_sc_hd__a21oi_1
X_0977_ VPWR VGND VGND VPWR _0991_/B _0978_/A _0977_/B sky130_fd_sc_hd__nand2_1
XPHY_EDGE_ROW_23_Right_23 VPWR VGND VPWR VGND sky130_fd_sc_hd__decap_3
XFILLER_18_134 VPWR VGND VPWR VGND sky130_fd_sc_hd__decap_6
XPHY_EDGE_ROW_14_Right_14 VPWR VGND VPWR VGND sky130_fd_sc_hd__decap_3
XPHY_EDGE_ROW_2_Left_34 VPWR VGND VPWR VGND sky130_fd_sc_hd__decap_3
X_0831_ VPWR VGND VGND VPWR _0839_/B _0833_/A _0831_/B sky130_fd_sc_hd__nand2_1
X_0762_ VPWR VGND VGND VPWR _0762_/A _0763_/B _0762_/B sky130_fd_sc_hd__nand2_1
X_0693_ VGND VPWR VPWR VGND _0693_/A _0693_/Y sky130_fd_sc_hd__clkinv_2
X_0900_ VPWR VGND VGND VPWR _0914_/B _0901_/A _0900_/B sky130_fd_sc_hd__nand2_1
X_0814_ VPWR VGND VGND VPWR _0814_/A _0819_/B _0814_/B sky130_fd_sc_hd__nand2_1
X_1030_ VPWR VGND VGND VPWR _1030_/A _1055_/B _1030_/B sky130_fd_sc_hd__nand2_1
X_0745_ VPWR VGND VGND VPWR _0789_/A _0746_/B _0746_/A sky130_fd_sc_hd__or2_1
X_0676_ VPWR VGND VPWR VGND _0678_/A _0676_/A sky130_fd_sc_hd__inv_2
XFILLER_12_129 VPWR VGND VPWR VGND sky130_fd_sc_hd__decap_6
X_0530_ VPWR VGND VPWR VGND _0799_/C B[4] sky130_fd_sc_hd__inv_2
XFILLER_7_133 VPWR VGND VPWR VGND sky130_fd_sc_hd__decap_3
X_1013_ VPWR VGND VGND VPWR _1015_/A _1014_/B _1014_/A sky130_fd_sc_hd__or2_1
X_0659_ VPWR VGND VGND VPWR A[6] _0660_/A _0659_/B sky130_fd_sc_hd__nand2_1
XPHY_EDGE_ROW_4_Right_4 VPWR VGND VPWR VGND sky130_fd_sc_hd__decap_3
X_0728_ VPWR VGND VGND VPWR _0732_/A _0728_/Y _0728_/B sky130_fd_sc_hd__nand2_1
XPHY_EDGE_ROW_31_Left_63 VPWR VGND VPWR VGND sky130_fd_sc_hd__decap_3
XFILLER_27_69 VPWR VGND VPWR VGND sky130_fd_sc_hd__decap_3
XFILLER_4_18 VPWR VGND VPWR VGND sky130_fd_sc_hd__decap_6
XFILLER_4_125 VGND VPWR VPWR VGND sky130_ef_sc_hd__decap_12
X_0993_ VPWR VGND VGND VPWR _1017_/A _0993_/Y _1016_/A sky130_fd_sc_hd__nand2_1
XFILLER_0_172 VGND VPWR VPWR VGND sky130_ef_sc_hd__decap_12
XFILLER_5_50 VPWR VGND VPWR VGND sky130_fd_sc_hd__decap_6
X_0976_ VGND VPWR VGND VPWR _0976_/A _0977_/B _0975_/A sky130_fd_sc_hd__or2b_1
XFILLER_27_135 VPWR VGND VPWR VGND sky130_fd_sc_hd__decap_8
XFILLER_4_3 VPWR VGND VPWR VGND sky130_fd_sc_hd__decap_6
XFILLER_25_80 VGND VPWR VPWR VGND sky130_ef_sc_hd__decap_12
X_0830_ VGND VPWR _0829_/B _0829_/C _0831_/B _0829_/A VPWR VGND sky130_fd_sc_hd__o21ai_1
XFILLER_18_102 VGND VPWR VPWR VGND sky130_ef_sc_hd__decap_12
X_0692_ VPWR VGND VGND VPWR B[7] _0761_/A A[1] sky130_fd_sc_hd__nand2_1
X_0761_ VGND VPWR VGND VPWR _0761_/A _0762_/B _0697_/B sky130_fd_sc_hd__or2b_1
X_0959_ VPWR VGND VGND VPWR _0959_/A _0960_/B _0959_/B sky130_fd_sc_hd__nand2_1
X_0813_ VPWR VGND VGND VPWR _0819_/A _0814_/B _0814_/A sky130_fd_sc_hd__or2_1
X_0744_ VPWR VGND VPWR VGND _0661_/A _0743_/X _0746_/A _0776_/A sky130_fd_sc_hd__o21bai_1
X_0675_ VGND VPWR _0675_/B _0676_/A _0675_/A VPWR VGND sky130_fd_sc_hd__xnor2_1
X_1089_ _1089_/Q _1102_/CLK _1089_/D VPWR VGND VPWR VGND sky130_fd_sc_hd__dfxtp_1
XFILLER_7_101 VPWR VGND VPWR VGND sky130_fd_sc_hd__decap_8
X_1012_ VGND VPWR VPWR VGND _1106_/Q _1014_/A _1012_/B sky130_fd_sc_hd__xor2_1
XFILLER_22_81 VPWR VGND VPWR VGND sky130_fd_sc_hd__decap_3
X_0727_ VPWR VGND VGND VPWR _0727_/A _0728_/B _0727_/B sky130_fd_sc_hd__nand2_1
XFILLER_27_26 VGND VPWR VPWR VGND sky130_fd_sc_hd__decap_4
X_0658_ VPWR VGND VGND VPWR A[5] _0665_/A B[2] sky130_fd_sc_hd__nand2_1
XFILLER_4_137 VPWR VGND VPWR VGND sky130_fd_sc_hd__decap_3
X_0589_ VPWR VGND VGND VPWR _0590_/B _0590_/A _0591_/A sky130_fd_sc_hd__nor2_1
XFILLER_3_181 VPWR VGND VPWR VGND sky130_fd_sc_hd__decap_8
XFILLER_0_184 VPWR VGND VPWR VGND sky130_fd_sc_hd__decap_6
XFILLER_0_162 VPWR VGND VPWR VGND sky130_fd_sc_hd__decap_6
X_0992_ VPWR VGND VGND VPWR _0992_/X _1016_/A _1017_/A sky130_fd_sc_hd__or2_1
XFILLER_14_71 VGND VPWR VPWR VGND sky130_ef_sc_hd__decap_12
X_0975_ VGND VPWR VGND VPWR _0975_/A _0991_/B _0976_/A sky130_fd_sc_hd__or2b_1
XFILLER_10_29 VPWR VGND VPWR VGND sky130_fd_sc_hd__decap_3
XFILLER_18_114 VPWR VGND VPWR VGND sky130_fd_sc_hd__decap_8
X_0760_ VPWR VGND VGND VPWR _0763_/A _0764_/B _0764_/A sky130_fd_sc_hd__or2_1
X_0691_ VGND VPWR _0690_/Y _0684_/A _0727_/B _0685_/A VPWR VGND sky130_fd_sc_hd__o21ai_1
XFILLER_21_17 VGND VPWR VPWR VGND sky130_ef_sc_hd__decap_12
X_0958_ VPWR VGND VGND VPWR _1092_/Q _0959_/B Y[9] sky130_fd_sc_hd__nand2_1
X_0889_ VPWR VGND VGND VPWR _0889_/A _0890_/A _0902_/B sky130_fd_sc_hd__nand2_1
X_0812_ VPWR VGND VPWR VGND _0814_/A _0812_/A sky130_fd_sc_hd__inv_2
X_0743_ _0743_/X _0829_/A _0742_/B _0661_/A _0742_/C VPWR VGND VGND VPWR sky130_fd_sc_hd__o31a_1
Xclkbuf_1_0__f_clk VGND VPWR clkbuf_0_clk/X clkbuf_1_0__f_clk/X VPWR VGND sky130_fd_sc_hd__clkbuf_4
X_0674_ VPWR VGND VGND VPWR _0674_/A _0675_/B _0693_/A sky130_fd_sc_hd__nand2_1
X_1088_ _1088_/Q _1102_/CLK _1088_/D VPWR VGND VPWR VGND sky130_fd_sc_hd__dfxtp_1
X_1011_ VPWR VGND VGND VPWR _1011_/A _1012_/B _1011_/B sky130_fd_sc_hd__nand2_1
XFILLER_7_113 VGND VPWR VPWR VGND sky130_ef_sc_hd__decap_12
XFILLER_7_146 VGND VPWR VPWR VGND sky130_ef_sc_hd__decap_12
XFILLER_8_40 VGND VPWR VPWR VGND sky130_ef_sc_hd__decap_12
X_0726_ VPWR VGND VGND VPWR _0732_/A _0727_/B _0727_/A sky130_fd_sc_hd__or2_1
X_0657_ VGND VPWR VPWR VGND _0729_/B _0685_/A _0657_/B sky130_fd_sc_hd__xor2_1
X_0588_ VPWR VGND VPWR VGND _0590_/A _0588_/A sky130_fd_sc_hd__inv_2
X_0709_ VPWR VGND VPWR VGND A[4] A[5] B[3] _0748_/A B[4] sky130_fd_sc_hd__a22o_1
XFILLER_12_3 VPWR VGND VPWR VGND sky130_fd_sc_hd__decap_8
XFILLER_28_81 VPWR VGND VPWR VGND sky130_fd_sc_hd__decap_3
X_0991_ VPWR VGND VGND VPWR _0991_/A _1017_/A _0991_/B sky130_fd_sc_hd__nand2_1
XFILLER_5_41 VPWR VGND VPWR VGND sky130_fd_sc_hd__decap_6
X_0974_ VGND VPWR VGND VPWR _0976_/A _1102_/Q _0959_/A _0959_/B sky130_fd_sc_hd__a21bo_1
XFILLER_26_170 VPWR VGND VPWR VGND sky130_fd_sc_hd__decap_8
X_0690_ VGND VPWR VPWR VGND _0690_/A _0690_/Y sky130_fd_sc_hd__clkinv_2
Xclkbuf_1_1__f_g_fast.genblk1.g_f2.g_cg.u_cg_p.gclk VGND VPWR clkbuf_0_g_fast.genblk1.g_f2.g_cg.u_cg_p.gclk/X
+ _1108_/CLK VPWR VGND sky130_fd_sc_hd__clkbuf_4
X_0957_ VPWR VGND VGND VPWR _0959_/A _1092_/Q Y[9] sky130_fd_sc_hd__or2_1
XPHY_EDGE_ROW_10_Right_10 VPWR VGND VPWR VGND sky130_fd_sc_hd__decap_3
X_0888_ VPWR VGND VGND VPWR _0902_/B _0888_/B _0899_/B _0887_/B sky130_fd_sc_hd__nand3b_1
XFILLER_11_84 VGND VPWR VPWR VGND sky130_fd_sc_hd__decap_4
XPHY_EDGE_ROW_6_Left_38 VPWR VGND VPWR VGND sky130_fd_sc_hd__decap_3
X_0811_ VPWR VGND VGND VPWR _0811_/A _0812_/A _0833_/B sky130_fd_sc_hd__nand2_1
X_0742_ VPWR VGND VPWR VGND _0742_/B _0742_/C _0829_/A _0776_/A sky130_fd_sc_hd__or3_1
XFILLER_14_184 VPWR VGND VPWR VGND sky130_fd_sc_hd__decap_6
X_0673_ VPWR VGND VPWR VGND A[3] A[4] B[3] _0693_/A B[4] sky130_fd_sc_hd__a22o_1
XFILLER_20_165 VPWR VGND VPWR VGND sky130_fd_sc_hd__decap_3
X_1087_ _1087_/Q _1102_/CLK _1087_/D VPWR VGND VPWR VGND sky130_fd_sc_hd__dfxtp_1
X_1010_ VPWR VGND VGND VPWR _1096_/Q _1011_/B Y[13] sky130_fd_sc_hd__nand2_1
XFILLER_22_50 VPWR VGND VPWR VGND sky130_fd_sc_hd__decap_6
XFILLER_7_125 VPWR VGND VPWR VGND sky130_fd_sc_hd__decap_8
XFILLER_7_158 VGND VPWR VPWR VGND sky130_fd_sc_hd__decap_4
X_0725_ VPWR VGND VPWR VGND _0727_/A _0725_/A sky130_fd_sc_hd__inv_2
X_0587_ VGND VPWR VPWR VGND _0587_/A _0588_/A _0587_/B sky130_fd_sc_hd__xor2_1
X_0656_ VPWR VGND VGND VPWR _0730_/A _0657_/B _0729_/A sky130_fd_sc_hd__nand2_1
XFILLER_8_52 VPWR VGND VPWR VGND sky130_fd_sc_hd__decap_6
XFILLER_8_85 VGND VPWR VPWR VGND sky130_ef_sc_hd__decap_12
XPHY_EDGE_ROW_9_Left_41 VPWR VGND VPWR VGND sky130_fd_sc_hd__decap_3
XPHY_EDGE_ROW_8_Right_8 VPWR VGND VPWR VGND sky130_fd_sc_hd__decap_3
X_0708_ VPWR VGND VPWR VGND _0780_/B _0799_/C _0769_/C _0804_/B _0710_/A sky130_fd_sc_hd__or4_1
X_0639_ VGND VPWR VPWR VGND _0639_/A _0857_/A _0639_/B sky130_fd_sc_hd__xor2_1
XFILLER_28_93 VGND VPWR VPWR VGND sky130_ef_sc_hd__decap_12
X_0990_ VPWR VGND VGND VPWR _1004_/B _1016_/A _1003_/B sky130_fd_sc_hd__nand2_1
XFILLER_24_29 VPWR VGND VPWR VGND sky130_fd_sc_hd__decap_8
X_0973_ VGND VPWR VPWR VGND _1103_/Q _0975_/A _0973_/B sky130_fd_sc_hd__xor2_1
XFILLER_24_108 VPWR VGND VPWR VGND sky130_fd_sc_hd__decap_6
XPHY_EDGE_ROW_22_Left_54 VPWR VGND VPWR VGND sky130_fd_sc_hd__decap_3
X_0956_ VGND VPWR _1118_/D _0956_/B _0956_/A _0966_/A VPWR VGND sky130_fd_sc_hd__and3_1
XFILLER_23_163 VGND VPWR VPWR VGND sky130_fd_sc_hd__decap_4
X_0887_ VPWR VGND VGND VPWR _0887_/A _0889_/A _0887_/B sky130_fd_sc_hd__nand2_1
X_0810_ VPWR VGND VGND VPWR _0810_/A _0833_/B _0810_/B sky130_fd_sc_hd__nand2_1
X_0741_ VGND VPWR _0741_/B _0742_/C _0741_/A VPWR VGND sky130_fd_sc_hd__xnor2_1
X_0672_ VPWR VGND VPWR VGND _0750_/B _0799_/C _0769_/C _0780_/B _0674_/A sky130_fd_sc_hd__or4_1
XFILLER_2_3 VPWR VGND VPWR VGND sky130_fd_sc_hd__decap_8
XFILLER_20_111 VPWR VGND VPWR VGND sky130_fd_sc_hd__decap_6
X_0939_ VPWR VGND VPWR VGND _0942_/B _0939_/A sky130_fd_sc_hd__inv_2
X_1086_ _1086_/Q _1102_/CLK _1086_/D VPWR VGND VPWR VGND sky130_fd_sc_hd__dfxtp_1
X_0724_ VPWR VGND VGND VPWR _0724_/A _0725_/A _0724_/B sky130_fd_sc_hd__nand2_1
X_0586_ VPWR VGND VGND VPWR _0586_/A _0587_/B _0586_/B sky130_fd_sc_hd__nand2_1
XFILLER_8_97 VGND VPWR VPWR VGND sky130_fd_sc_hd__decap_4
X_0655_ VGND VPWR _0654_/B _0654_/C _0729_/A _0804_/A VPWR VGND sky130_fd_sc_hd__o21ai_1
X_1069_ VPWR VGND VPWR VGND _1068_/X _1067_/X _0860_/A _1127_/D sky130_fd_sc_hd__a21oi_1
X_0707_ VPWR VGND VGND VPWR A[3] _0711_/A B[5] sky130_fd_sc_hd__nand2_1
X_0569_ VPWR VGND VGND VPWR B[5] _0596_/A _0853_/B sky130_fd_sc_hd__nand2_1
X_0638_ VPWR VGND VGND VPWR _0638_/A _0639_/B _0638_/B sky130_fd_sc_hd__nand2_1
XFILLER_5_76 VPWR VGND VPWR VGND sky130_fd_sc_hd__decap_6
XFILLER_14_85 VPWR VGND VPWR VGND sky130_fd_sc_hd__decap_6
X_0972_ VPWR VGND VGND VPWR _0972_/A _0973_/B _0972_/B sky130_fd_sc_hd__nand2_1
XFILLER_25_40 VPWR VGND VPWR VGND sky130_fd_sc_hd__decap_3
X_0886_ VPWR VGND VGND VPWR _0888_/B _0887_/A _0899_/B sky130_fd_sc_hd__nand2_1
X_0955_ VPWR VGND VGND VPWR _0955_/A _0966_/A _0955_/B sky130_fd_sc_hd__nand2_1
X_0740_ VPWR VGND VGND VPWR _0740_/A _0741_/B _0778_/A sky130_fd_sc_hd__nand2_1
XFILLER_28_3 VPWR VGND VPWR VGND sky130_fd_sc_hd__decap_8
X_0869_ VPWR VGND VPWR VGND _0871_/A _0869_/A sky130_fd_sc_hd__inv_2
X_0671_ VPWR VGND VGND VPWR A[2] _0675_/A B[5] sky130_fd_sc_hd__nand2_1
X_1085_ _1085_/Q _1102_/CLK _1085_/D VPWR VGND VPWR VGND sky130_fd_sc_hd__dfxtp_1
X_0938_ VPWR VGND VGND VPWR _0953_/B _0939_/A _0938_/B sky130_fd_sc_hd__nand2_1
X_0723_ VPWR VGND VPWR VGND _0720_/B _0735_/B _0720_/A _0724_/B sky130_fd_sc_hd__a21o_1
XFILLER_8_32 VGND VPWR VPWR VGND sky130_fd_sc_hd__decap_4
X_0585_ VPWR VGND VGND VPWR _0585_/A _0586_/B _0585_/B sky130_fd_sc_hd__nand2_1
X_0654_ VPWR VGND VPWR VGND _0654_/B _0654_/C _0804_/A _0730_/A sky130_fd_sc_hd__or3_1
X_1068_ VPWR VGND VPWR VGND _1066_/B _1066_/A Y[17] _1068_/X sky130_fd_sc_hd__a21o_1
Xclkbuf_0_g_fast.g_acc_cg.u_cg_a.gclk VGND VPWR g_fast.g_acc_cg.u_cg_a.u_icg/GCLK
+ clkbuf_0_g_fast.g_acc_cg.u_cg_a.gclk/X VPWR VGND sky130_fd_sc_hd__clkbuf_4
X_0706_ VGND VPWR VPWR VGND _0736_/B _0706_/Y sky130_fd_sc_hd__clkinv_2
X_0637_ VGND VPWR VGND VPWR _0637_/A _0857_/B _0645_/A sky130_fd_sc_hd__or2b_1
X_0568_ VGND VPWR VGND VPWR _0590_/B _0552_/B _0553_/A _0552_/A sky130_fd_sc_hd__a21bo_1
XFILLER_10_3 VGND VPWR VPWR VGND sky130_ef_sc_hd__decap_12
XFILLER_14_20 VPWR VGND VPWR VGND sky130_fd_sc_hd__decap_3
X_0971_ VPWR VGND VGND VPWR _1093_/Q _0972_/B Y[10] sky130_fd_sc_hd__nand2_1
Xclkbuf_0_clk_regs VGND VPWR delaybuf_2_clk/X clkbuf_0_clk_regs/X VPWR VGND sky130_fd_sc_hd__clkbuf_4
XFILLER_26_162 VGND VPWR VPWR VGND sky130_fd_sc_hd__decap_4
X_0954_ VPWR VGND VGND VPWR _0956_/A _0955_/B _0955_/A sky130_fd_sc_hd__or2_1
X_0885_ VPWR VGND VGND VPWR _1086_/Q _0899_/B Y[3] sky130_fd_sc_hd__nand2_1
XFILLER_23_187 VPWR VGND VPWR VGND sky130_fd_sc_hd__decap_3
Xdelaybuf_1_clk VGND VPWR delaybuf_1_clk/A delaybuf_2_clk/A VPWR VGND sky130_fd_sc_hd__clkbuf_4
XFILLER_11_43 VPWR VGND VPWR VGND sky130_fd_sc_hd__decap_8
XFILLER_20_124 VPWR VGND VPWR VGND sky130_fd_sc_hd__decap_6
X_0670_ VPWR VGND VGND VPWR _0670_/A _0678_/C _0670_/B sky130_fd_sc_hd__nand2_1
X_1084_ _1084_/Q _1102_/CLK _1084_/D VPWR VGND VPWR VGND sky130_fd_sc_hd__dfxtp_1
X_0799_ VPWR VGND VPWR VGND _0826_/B _0829_/B _0799_/C _0829_/A _0849_/B sky130_fd_sc_hd__or4_1
X_0868_ VPWR VGND VGND VPWR _1084_/Q _0877_/A Y[1] sky130_fd_sc_hd__nand2_1
X_0937_ VGND VPWR VGND VPWR _0937_/A _0938_/B _0936_/A sky130_fd_sc_hd__or2b_1
X_0722_ VGND VPWR VGND VPWR _0735_/A _0724_/A _0735_/B sky130_fd_sc_hd__or2b_1
XFILLER_6_183 VPWR VGND VPWR VGND sky130_fd_sc_hd__decap_6
X_0653_ VPWR VGND VGND VPWR _0619_/A _0652_/Y _0618_/A _0654_/C sky130_fd_sc_hd__o21a_1
X_1067_ VGND VPWR VGND VPWR _1081_/A _1067_/X Y[17] sky130_fd_sc_hd__or2b_1
X_0584_ VPWR VGND VGND VPWR _0586_/A _0585_/B _0585_/A sky130_fd_sc_hd__or2_1
X_0705_ VPWR VGND VGND VPWR _0713_/B _0736_/B _0713_/A sky130_fd_sc_hd__nand2_1
X_0636_ _0645_/A A[1] _0853_/A _0659_/B _0853_/B VGND VPWR VPWR VGND sky130_fd_sc_hd__and4_1
X_0567_ VPWR VGND VGND VPWR _0633_/A _0632_/B _0632_/A sky130_fd_sc_hd__or2_1
XPHY_EDGE_ROW_26_Right_26 VPWR VGND VPWR VGND sky130_fd_sc_hd__decap_3
XPHY_EDGE_ROW_17_Right_17 VPWR VGND VPWR VGND sky130_fd_sc_hd__decap_3
X_1119_ VGND VPWR VGND VPWR Y[9] _1119_/D clkload0/A sky130_fd_sc_hd__dfxtp_4
X_0619_ VGND VPWR _0619_/B _0620_/A _0619_/A VPWR VGND sky130_fd_sc_hd__xnor2_1
XFILLER_30_42 VGND VPWR VPWR VGND sky130_fd_sc_hd__decap_4
X_0970_ VPWR VGND VGND VPWR _0972_/A _1093_/Q Y[10] sky130_fd_sc_hd__or2_1
XFILLER_26_185 VGND VPWR VPWR VGND sky130_fd_sc_hd__decap_4
XFILLER_26_152 VPWR VGND VPWR VGND sky130_fd_sc_hd__decap_6
XFILLER_26_141 VPWR VGND VPWR VGND sky130_fd_sc_hd__decap_8
X_0953_ VPWR VGND VGND VPWR _0953_/A _0955_/A _0953_/B sky130_fd_sc_hd__nand2_1
X_0884_ VPWR VGND VGND VPWR _0888_/B _1086_/Q Y[3] sky130_fd_sc_hd__or2_1
XPHY_EDGE_ROW_26_Left_58 VPWR VGND VPWR VGND sky130_fd_sc_hd__decap_3
X_1083_ _1083_/Q _1108_/CLK _1083_/D VPWR VGND VPWR VGND sky130_fd_sc_hd__dfxtp_1
X_0798_ VGND VPWR VGND VPWR _0814_/B _0786_/A _0786_/C _0786_/B sky130_fd_sc_hd__a21bo_1
X_0867_ VPWR VGND VGND VPWR _0867_/A _0871_/B _0867_/B sky130_fd_sc_hd__nand2_1
X_0936_ VGND VPWR VGND VPWR _0936_/A _0953_/B _0937_/A sky130_fd_sc_hd__or2b_1
XFILLER_22_98 VPWR VGND VPWR VGND sky130_fd_sc_hd__decap_3
XFILLER_0_3 VGND VPWR VPWR VGND sky130_ef_sc_hd__decap_12
XFILLER_8_67 VPWR VGND VPWR VGND sky130_fd_sc_hd__decap_3
X_1066_ VPWR VGND VGND VPWR _1066_/A _1081_/A _1066_/B sky130_fd_sc_hd__nand2_1
X_0721_ VPWR VGND VGND VPWR _0735_/B _0721_/A _0721_/B sky130_fd_sc_hd__or2_1
X_0583_ VPWR VGND VPWR VGND _0585_/A _0583_/A sky130_fd_sc_hd__inv_2
X_0919_ VPWR VGND VGND VPWR _1089_/Q _0920_/B Y[6] sky130_fd_sc_hd__nand2_1
X_0652_ VGND VPWR VPWR VGND _0652_/A _0652_/Y sky130_fd_sc_hd__clkinv_2
XFILLER_3_121 VGND VPWR VPWR VGND sky130_ef_sc_hd__decap_12
XPHY_EDGE_ROW_29_Left_61 VPWR VGND VPWR VGND sky130_fd_sc_hd__decap_3
X_0704_ VPWR VGND _0713_/A _0663_/Y B[2] A[5] _0664_/A VGND VPWR sky130_fd_sc_hd__a31o_1
XPHY_EDGE_ROW_13_Left_45 VPWR VGND VPWR VGND sky130_fd_sc_hd__decap_3
X_0635_ VGND VPWR VPWR VGND _0635_/A _0637_/A _0635_/B sky130_fd_sc_hd__xor2_1
X_0566_ VPWR VGND VPWR VGND _0638_/B _0632_/A _0638_/A _0639_/A sky130_fd_sc_hd__a21boi_1
X_1049_ VPWR VGND VGND VPWR _1063_/A _1049_/Y _1062_/B sky130_fd_sc_hd__nand2_1
X_1118_ VGND VPWR VGND VPWR Y[8] _1118_/D clkload0/A sky130_fd_sc_hd__dfxtp_4
XFILLER_5_57 VPWR VGND VPWR VGND sky130_fd_sc_hd__decap_3
X_0549_ VPWR VGND VPWR VGND _0559_/A _0551_/A _0560_/A _0559_/B sky130_fd_sc_hd__a21boi_1
X_0618_ VPWR VGND VGND VPWR _0618_/A _0619_/B _0652_/A sky130_fd_sc_hd__nand2_1
XFILLER_30_65 VPWR VGND VPWR VGND sky130_fd_sc_hd__decap_3
XFILLER_17_164 VGND VPWR VPWR VGND sky130_fd_sc_hd__decap_4
X_0883_ VGND VPWR _1112_/D _0956_/B _0883_/A _0883_/C VPWR VGND sky130_fd_sc_hd__and3_1
X_0952_ VPWR VGND VPWR VGND _0955_/B _0952_/A sky130_fd_sc_hd__inv_2
XFILLER_14_134 VPWR VGND VPWR VGND sky130_fd_sc_hd__decap_6
XPHY_EDGE_ROW_1_Left_33 VPWR VGND VPWR VGND sky130_fd_sc_hd__decap_3
X_1082_ VPWR VGND VPWR VGND _1081_/Y _1080_/X hold7/X _1129_/D sky130_fd_sc_hd__a21oi_1
X_0797_ VPWR VGND VPWR VGND _1093_/D _0797_/A sky130_fd_sc_hd__inv_2
XFILLER_20_148 VGND VPWR VPWR VGND sky130_fd_sc_hd__decap_4
X_0866_ VGND VPWR VPWR VGND Y[1] _0867_/B sky130_fd_sc_hd__clkinv_2
XFILLER_9_182 VPWR VGND VPWR VGND sky130_fd_sc_hd__decap_8
X_0935_ VGND VPWR VGND VPWR _0937_/A _1099_/Q _0920_/A _0920_/B sky130_fd_sc_hd__a21bo_1
X_1065_ VPWR VGND VPWR VGND _1066_/B _1065_/A sky130_fd_sc_hd__inv_2
XFILLER_26_3 VGND VPWR VPWR VGND sky130_fd_sc_hd__decap_4
X_0720_ VPWR VGND VGND VPWR _0720_/A _0735_/A _0720_/B sky130_fd_sc_hd__nand2_1
X_0651_ VPWR VGND VPWR VGND _0826_/A B[6] sky130_fd_sc_hd__inv_2
X_0582_ VGND VPWR VPWR VGND _0604_/A _0583_/A _0582_/B sky130_fd_sc_hd__xor2_1
X_0849_ VPWR VGND VGND VPWR _0849_/A _0849_/B _0849_/Y sky130_fd_sc_hd__nor2_1
X_0918_ VPWR VGND VGND VPWR _0920_/A _1089_/Q Y[6] sky130_fd_sc_hd__or2_1
X_0703_ VPWR VGND _0713_/B _0703_/B _0776_/B VPWR VGND sky130_fd_sc_hd__and2_1
XFILLER_3_133 VPWR VGND VPWR VGND sky130_fd_sc_hd__decap_6
X_1048_ VPWR VGND VGND VPWR _1048_/X _1062_/B _1063_/A sky130_fd_sc_hd__or2_1
X_0634_ VPWR VGND VGND VPWR _0634_/A _0635_/B _0634_/B sky130_fd_sc_hd__nand2_1
X_0565_ VPWR VGND VGND VPWR _0565_/A _0638_/B _0565_/B sky130_fd_sc_hd__nand2_1
X_1117_ VGND VPWR VGND VPWR Y[7] _1117_/D clkload0/A sky130_fd_sc_hd__dfxtp_4
XPHY_EDGE_ROW_3_Right_3 VPWR VGND VPWR VGND sky130_fd_sc_hd__decap_3
XPHY_EDGE_ROW_30_Left_62 VPWR VGND VPWR VGND sky130_fd_sc_hd__decap_3
Xclkbuf_1_1__f_clk VGND VPWR clkbuf_0_clk/X clkbuf_1_1__f_clk/X VPWR VGND sky130_fd_sc_hd__clkbuf_4
XFILLER_0_147 VPWR VGND VPWR VGND sky130_fd_sc_hd__decap_8
X_0548_ VPWR VGND VPWR VGND _0701_/C _0695_/B _0750_/B _0608_/B _0559_/A sky130_fd_sc_hd__or4_1
X_0617_ VPWR VGND VPWR VGND A[2] A[3] B[3] _0652_/A B[4] sky130_fd_sc_hd__a22o_1
XFILLER_14_56 VGND VPWR VPWR VGND sky130_ef_sc_hd__decap_12
XFILLER_25_99 VPWR VGND VPWR VGND sky130_fd_sc_hd__decap_6
XFILLER_25_22 VPWR VGND VPWR VGND sky130_fd_sc_hd__decap_8
XFILLER_17_121 VPWR VGND VPWR VGND sky130_fd_sc_hd__decap_8
X_0882_ VPWR VGND VGND VPWR _0882_/A _0883_/C _0882_/B sky130_fd_sc_hd__nand2_1
X_0951_ VPWR VGND VGND VPWR _0966_/B _0952_/A _0951_/B sky130_fd_sc_hd__nand2_1
XFILLER_23_113 VGND VPWR VPWR VGND sky130_ef_sc_hd__decap_12
XFILLER_11_57 VGND VPWR VPWR VGND sky130_ef_sc_hd__decap_12
X_1081_ VPWR VGND VGND VPWR _1081_/A _1081_/B _1081_/Y _1081_/C sky130_fd_sc_hd__nand3_1
X_0796_ VPWR VGND VGND VPWR _0794_/B _0795_/X _0797_/A _0846_/A _0795_/B sky130_fd_sc_hd__o2bb2ai_1
X_0865_ VGND VPWR VPWR VGND _1084_/Q _0867_/A sky130_fd_sc_hd__clkinv_2
X_0934_ VGND VPWR VPWR VGND _1100_/Q _0936_/A _0934_/B sky130_fd_sc_hd__xor2_1
XFILLER_7_109 VPWR VGND VPWR VGND sky130_fd_sc_hd__decap_3
X_1064_ VGND VPWR _1044_/B _1071_/B _1065_/A _1062_/A VPWR VGND sky130_fd_sc_hd__o21ai_1
XFILLER_10_182 VPWR VGND VPWR VGND sky130_fd_sc_hd__decap_8
X_0650_ VPWR VGND VPWR VGND _0729_/B _0650_/A sky130_fd_sc_hd__inv_2
X_0581_ VPWR VGND VGND VPWR _0605_/A _0582_/B _0581_/B sky130_fd_sc_hd__nand2_1
X_0848_ VGND VPWR VGND VPWR _1106_/D _0835_/A _0834_/B _0834_/A sky130_fd_sc_hd__a21bo_1
X_0779_ VPWR VGND VGND VPWR _0741_/A _0778_/Y _0740_/A _0780_/C sky130_fd_sc_hd__o21a_1
X_0917_ VGND VPWR _1115_/D _0956_/B _0917_/A _0927_/A VPWR VGND sky130_fd_sc_hd__and3_1
Xhold7 hold7/X reset VPWR VGND VGND VPWR sky130_fd_sc_hd__dlygate4sd3_1
X_1047_ VPWR VGND VPWR VGND _1045_/Y _1021_/A _1046_/Y _1063_/A sky130_fd_sc_hd__a21o_1
X_0702_ VPWR VGND VPWR VGND A[6] A[7] _0659_/B _0703_/B B[2] sky130_fd_sc_hd__a22o_1
X_0564_ VPWR VGND VPWR VGND _0639_/A _0564_/A sky130_fd_sc_hd__inv_2
X_1116_ Y[6] clkload0/A _1116_/D VPWR VGND VPWR VGND sky130_fd_sc_hd__dfxtp_2
X_0633_ VPWR VGND VGND VPWR _0633_/A _0642_/B _0633_/B sky130_fd_sc_hd__nand2_1
XFILLER_28_11 VPWR VGND VPWR VGND sky130_fd_sc_hd__decap_3
XPHY_EDGE_ROW_22_Right_22 VPWR VGND VPWR VGND sky130_fd_sc_hd__decap_3
XPHY_EDGE_ROW_13_Right_13 VPWR VGND VPWR VGND sky130_fd_sc_hd__decap_3
X_0616_ VPWR VGND VPWR VGND _0695_/B _0799_/C _0769_/C _0750_/B _0618_/A sky130_fd_sc_hd__or4_1
XPHY_EDGE_ROW_31_Right_31 VPWR VGND VPWR VGND sky130_fd_sc_hd__decap_3
X_0547_ VPWR VGND VPWR VGND _0695_/B A[2] sky130_fd_sc_hd__inv_2
XFILLER_23_125 VGND VPWR VPWR VGND sky130_fd_sc_hd__decap_4
X_0881_ VPWR VGND VGND VPWR _0883_/A _0882_/B _0882_/A sky130_fd_sc_hd__or2_1
X_0950_ VGND VPWR VGND VPWR _0950_/A _0951_/B _0949_/A sky130_fd_sc_hd__or2b_1
XFILLER_11_69 VGND VPWR VPWR VGND sky130_ef_sc_hd__decap_12
X_1080_ VPWR VGND VPWR VGND _1081_/C _1081_/A _1081_/B _1080_/X sky130_fd_sc_hd__a21o_1
X_0795_ VPWR VGND _0795_/X _0795_/B _0795_/A VPWR VGND sky130_fd_sc_hd__and2_1
X_0864_ VGND VPWR _1110_/D _0956_/B _0864_/A _0869_/A VPWR VGND sky130_fd_sc_hd__and3_1
XFILLER_13_180 VPWR VGND VPWR VGND sky130_fd_sc_hd__decap_8
X_0933_ VPWR VGND VGND VPWR _0933_/A _0934_/B _0933_/B sky130_fd_sc_hd__nand2_1
XFILLER_11_128 VPWR VGND VPWR VGND sky130_fd_sc_hd__decap_6
X_0580_ VPWR VGND VPWR VGND _0659_/B _0853_/A A[5] _0581_/B A[4] sky130_fd_sc_hd__a22o_1
XFILLER_6_165 VPWR VGND VPWR VGND sky130_fd_sc_hd__decap_3
X_0847_ VGND VPWR VGND VPWR _1105_/D _0819_/C _0819_/A _0819_/B sky130_fd_sc_hd__a21bo_1
X_1063_ VPWR VGND VGND VPWR _1063_/A _1066_/A _1063_/B sky130_fd_sc_hd__nand2_1
X_0778_ VGND VPWR VPWR VGND _0778_/A _0778_/Y sky130_fd_sc_hd__clkinv_2
X_0916_ VPWR VGND VGND VPWR _0916_/A _0927_/A _0916_/B sky130_fd_sc_hd__nand2_1
XFILLER_17_57 VGND VPWR VPWR VGND sky130_ef_sc_hd__decap_12
XFILLER_17_46 VGND VPWR VPWR VGND sky130_fd_sc_hd__decap_4
XFILLER_31_3 VGND VPWR VPWR VGND sky130_ef_sc_hd__decap_12
X_1046_ VGND VPWR _1055_/B _1030_/A _1046_/Y _1015_/A VPWR VGND sky130_fd_sc_hd__o21ai_1
X_0701_ VPWR VGND VPWR VGND _0826_/B _0742_/B _0701_/C _0829_/A _0776_/B sky130_fd_sc_hd__or4_1
X_0563_ VPWR VGND VGND VPWR B[3] _0564_/A _0853_/B sky130_fd_sc_hd__nand2_1
X_1115_ VGND VPWR VGND VPWR Y[5] _1115_/D clkload0/A sky130_fd_sc_hd__dfxtp_4
X_0632_ VPWR VGND VGND VPWR _0632_/A _0633_/B _0632_/B sky130_fd_sc_hd__nand2_1
XFILLER_28_23 VGND VPWR VPWR VGND sky130_fd_sc_hd__decap_4
XFILLER_0_127 VGND VPWR VPWR VGND sky130_ef_sc_hd__decap_12
XPHY_EDGE_ROW_17_Left_49 VPWR VGND VPWR VGND sky130_fd_sc_hd__decap_3
X_1029_ VPWR VGND VGND VPWR _1029_/A _1030_/B _1029_/B sky130_fd_sc_hd__nand2_1
X_0546_ VPWR VGND VPWR VGND _0750_/B A[3] sky130_fd_sc_hd__inv_2
X_0615_ VPWR VGND VGND VPWR A[1] _0619_/A B[5] sky130_fd_sc_hd__nand2_1
X_0529_ VPWR VGND VPWR VGND _0769_/C B[3] sky130_fd_sc_hd__inv_2
XFILLER_25_57 VPWR VGND VPWR VGND sky130_fd_sc_hd__decap_8
XFILLER_9_3 VGND VPWR VPWR VGND sky130_fd_sc_hd__decap_4
X_0880_ VGND VPWR VGND VPWR _0880_/A _0882_/A _0879_/Y sky130_fd_sc_hd__or2b_1
XFILLER_23_148 VPWR VGND VPWR VGND sky130_fd_sc_hd__decap_6
XFILLER_11_15 VGND VPWR VPWR VGND sky130_ef_sc_hd__decap_12
X_0932_ VPWR VGND VGND VPWR _1090_/Q _0933_/B Y[7] sky130_fd_sc_hd__nand2_1
X_0794_ VPWR VGND _0846_/A _0794_/B _0795_/A VPWR VGND sky130_fd_sc_hd__and2_1
XFILLER_22_36 VGND VPWR VPWR VGND sky130_fd_sc_hd__decap_4
X_0863_ VPWR VGND VGND VPWR _1083_/Q _0869_/A Y[0] sky130_fd_sc_hd__nand2_1
XPHY_EDGE_ROW_5_Left_37 VPWR VGND VPWR VGND sky130_fd_sc_hd__decap_3
X_0846_ VGND VPWR VGND VPWR _0846_/A _1104_/D _0795_/B sky130_fd_sc_hd__or2b_1
X_1062_ VPWR VGND VGND VPWR _1062_/A _1062_/B _1063_/B sky130_fd_sc_hd__nor2_1
X_0777_ VPWR VGND VGND VPWR B[7] _0816_/A A[3] sky130_fd_sc_hd__nand2_1
X_0915_ VPWR VGND VGND VPWR _0917_/A _0916_/B _0916_/A sky130_fd_sc_hd__or2_1
XFILLER_17_69 VGND VPWR VPWR VGND sky130_fd_sc_hd__decap_4
XFILLER_3_158 VPWR VGND VPWR VGND sky130_fd_sc_hd__decap_6
XFILLER_24_3 VPWR VGND VPWR VGND sky130_fd_sc_hd__decap_8
X_0700_ VPWR VGND VPWR VGND _0742_/B B[2] sky130_fd_sc_hd__inv_2
X_0562_ VPWR VGND VGND VPWR _0638_/A _0565_/B _0565_/A sky130_fd_sc_hd__or2_1
X_0631_ VGND VPWR VPWR VGND _0631_/A _1089_/D sky130_fd_sc_hd__clkinv_2
X_1114_ Y[4] clkload0/A _1114_/D VPWR VGND VPWR VGND sky130_fd_sc_hd__dfxtp_2
X_1045_ VPWR VGND VGND VPWR _1045_/A _1055_/B _1045_/Y sky130_fd_sc_hd__nor2_1
X_0829_ VPWR VGND VPWR VGND _0829_/B _0829_/C _0829_/A _0839_/B sky130_fd_sc_hd__or3_1
XFILLER_0_117 VPWR VGND VPWR VGND sky130_fd_sc_hd__decap_3
XFILLER_5_28 VGND VPWR VPWR VGND sky130_fd_sc_hd__decap_4
XPHY_EDGE_ROW_8_Left_40 VPWR VGND VPWR VGND sky130_fd_sc_hd__decap_3
X_1028_ VPWR VGND VGND VPWR _1030_/A _1029_/B _1029_/A sky130_fd_sc_hd__or2_1
X_0545_ VPWR VGND VPWR VGND _0701_/C _0659_/B sky130_fd_sc_hd__inv_2
XFILLER_14_37 VPWR VGND VPWR VGND sky130_fd_sc_hd__decap_3
X_0614_ VPWR VGND VGND VPWR _0614_/A _0622_/B _0614_/B sky130_fd_sc_hd__nand2_1
XPHY_EDGE_ROW_7_Right_7 VPWR VGND VPWR VGND sky130_fd_sc_hd__decap_3
XFILLER_29_165 VPWR VGND VPWR VGND sky130_fd_sc_hd__decap_3
XFILLER_20_80 VGND VPWR VPWR VGND sky130_fd_sc_hd__decap_4
X_0528_ _1108_/D B[6] A[7] B[7] A[6] VGND VPWR VPWR VGND sky130_fd_sc_hd__and4_1
XFILLER_17_113 VGND VPWR VPWR VGND sky130_fd_sc_hd__decap_4
XFILLER_2_29 VPWR VGND VPWR VGND sky130_fd_sc_hd__decap_6
XFILLER_11_27 VPWR VGND VPWR VGND sky130_fd_sc_hd__decap_6
X_0793_ VPWR VGND VGND VPWR _0793_/A _0794_/B _0793_/B sky130_fd_sc_hd__nand2_1
XPHY_EDGE_ROW_21_Left_53 VPWR VGND VPWR VGND sky130_fd_sc_hd__decap_3
X_0862_ VPWR VGND VGND VPWR _0864_/A _1083_/Q Y[0] sky130_fd_sc_hd__or2_1
X_0931_ VPWR VGND VGND VPWR _0933_/A _1090_/Q Y[7] sky130_fd_sc_hd__or2_1
X_1061_ VPWR VGND VPWR VGND _1060_/Y _1059_/X _0860_/A _1126_/D sky130_fd_sc_hd__a21oi_1
X_0845_ VPWR VGND VGND VPWR _0845_/A _1103_/D _0845_/B sky130_fd_sc_hd__nand2_1
X_0914_ VPWR VGND VGND VPWR _0914_/A _0916_/A _0914_/B sky130_fd_sc_hd__nand2_1
X_0776_ VPWR VGND VGND VPWR _0776_/A _0776_/B _0786_/C _0776_/C sky130_fd_sc_hd__nand3_1
X_0561_ VPWR VGND VPWR VGND _0565_/A _0561_/A sky130_fd_sc_hd__inv_2
X_0630_ VPWR VGND VGND VPWR _0631_/A _1100_/D _0630_/B sky130_fd_sc_hd__or2_1
X_1044_ VPWR VGND VGND VPWR _1044_/A _1062_/B _1044_/B sky130_fd_sc_hd__nand2_1
X_0828_ VGND VPWR VPWR VGND _0849_/A _0829_/C _0828_/B sky130_fd_sc_hd__xor2_1
X_0759_ VPWR VGND VPWR VGND _0764_/A _0759_/A sky130_fd_sc_hd__inv_2
XFILLER_17_3 VPWR VGND VPWR VGND sky130_fd_sc_hd__decap_6
X_1113_ Y[3] clkload0/A _1113_/D VPWR VGND VPWR VGND sky130_fd_sc_hd__dfxtp_2
X_1027_ VGND VPWR VPWR VGND _1107_/Q _1029_/A _1027_/B sky130_fd_sc_hd__xor2_1
X_0544_ VPWR VGND VPWR VGND _0608_/B _0853_/A sky130_fd_sc_hd__inv_2
X_0613_ VPWR VGND VGND VPWR _0622_/A _0614_/B _0614_/A sky130_fd_sc_hd__or2_1
XFILLER_30_15 VPWR VGND VPWR VGND sky130_fd_sc_hd__decap_3
XFILLER_29_144 VPWR VGND VPWR VGND sky130_fd_sc_hd__decap_8
Xfanout1 VGND VPWR _0982_/B _0956_/B VPWR VGND sky130_fd_sc_hd__clkbuf_2
XFILLER_26_114 VPWR VGND VPWR VGND sky130_fd_sc_hd__decap_3
XFILLER_17_169 VGND VPWR VPWR VGND sky130_fd_sc_hd__decap_4
X_0792_ VGND VPWR VGND VPWR _0792_/A _0793_/B _0752_/B sky130_fd_sc_hd__or2b_1
X_0861_ VPWR VGND _1109_/D enable _0956_/B VPWR VGND sky130_fd_sc_hd__and2_1
X_0930_ VGND VPWR _1116_/D _0956_/B _0930_/A _0940_/A VPWR VGND sky130_fd_sc_hd__and3_1
XPHY_EDGE_ROW_29_Right_29 VPWR VGND VPWR VGND sky130_fd_sc_hd__decap_3
X_1060_ VPWR VGND VGND VPWR _1070_/A _1060_/Y _1062_/A sky130_fd_sc_hd__nand2_1
XFILLER_10_120 VGND VPWR VPWR VGND sky130_ef_sc_hd__decap_12
XFILLER_6_157 VPWR VGND VPWR VGND sky130_fd_sc_hd__decap_8
X_0775_ VPWR VGND VPWR VGND _0776_/B _0776_/A _0776_/C _0786_/B sky130_fd_sc_hd__a21o_1
X_0913_ VPWR VGND VPWR VGND _0916_/B _0913_/A sky130_fd_sc_hd__inv_2
X_0844_ VGND VPWR VGND VPWR _0844_/A _1102_/D _0728_/B sky130_fd_sc_hd__or2b_1
X_0758_ VPWR VGND VGND VPWR _0758_/A _0759_/A _0758_/B sky130_fd_sc_hd__nand2_1
X_1043_ VPWR VGND VGND VPWR _1043_/A _1044_/B _1043_/B sky130_fd_sc_hd__nand2_1
X_0827_ _0828_/B _0825_/X _0827_/B VGND VPWR VPWR VGND sky130_fd_sc_hd__and2b_1
X_1112_ VGND VPWR VGND VPWR Y[2] _1112_/D clkload0/A sky130_fd_sc_hd__dfxtp_4
X_0560_ VGND VPWR VPWR VGND _0560_/A _0561_/A _0560_/B sky130_fd_sc_hd__xor2_1
XFILLER_0_85 VGND VPWR VPWR VGND sky130_ef_sc_hd__decap_12
XFILLER_0_74 VPWR VGND VPWR VGND sky130_fd_sc_hd__decap_8
Xclkbuf_1_0__f_clk_regs VGND VPWR clkbuf_0_clk_regs/X _1109_/CLK VPWR VGND sky130_fd_sc_hd__clkbuf_4
X_0689_ VGND VPWR VPWR VGND _0689_/A _1090_/D _0689_/B sky130_fd_sc_hd__xor2_1
X_0543_ VPWR VGND VPWR VGND _0659_/B _0853_/A A[3] _0559_/B A[2] sky130_fd_sc_hd__a22o_1
X_0612_ VPWR VGND VPWR VGND _0614_/A _0612_/A sky130_fd_sc_hd__inv_2
X_1026_ VPWR VGND VGND VPWR _1026_/A _1027_/B _1026_/B sky130_fd_sc_hd__nand2_1
Xfanout2 VPWR VGND _0804_/A _0826_/A VPWR VGND sky130_fd_sc_hd__buf_2
X_1009_ VPWR VGND VGND VPWR _1011_/A _1096_/Q Y[13] sky130_fd_sc_hd__or2_1
XFILLER_25_49 VPWR VGND VPWR VGND sky130_fd_sc_hd__decap_6
XFILLER_31_81 VPWR VGND VPWR VGND sky130_fd_sc_hd__decap_3
XFILLER_7_3 VGND VPWR VPWR VGND sky130_fd_sc_hd__decap_4
X_0791_ VPWR VGND VGND VPWR _0795_/A _0791_/A _0791_/B sky130_fd_sc_hd__or2_1
XFILLER_26_70 VGND VPWR VPWR VGND sky130_fd_sc_hd__decap_4
X_0860_ VPWR VGND VPWR VGND _0982_/B _0860_/A sky130_fd_sc_hd__inv_2
X_0989_ VPWR VGND VGND VPWR _0989_/A _1003_/B _0989_/B sky130_fd_sc_hd__nand2_1
X_0774_ VPWR VGND VPWR VGND _0803_/A _0769_/X _0773_/X _0776_/C sky130_fd_sc_hd__a21o_1
X_0843_ VGND VPWR VGND VPWR _1101_/D _0599_/A _0688_/A _0688_/B sky130_fd_sc_hd__a21bo_1
X_0912_ VPWR VGND VGND VPWR _0927_/B _0913_/A _0912_/B sky130_fd_sc_hd__nand2_1
X_1042_ VPWR VGND VGND VPWR _1044_/A _1043_/B _1043_/A sky130_fd_sc_hd__or2_1
XFILLER_23_71 VPWR VGND VPWR VGND sky130_fd_sc_hd__decap_8
X_1111_ VGND VPWR VGND VPWR Y[1] _1111_/D clkload0/A sky130_fd_sc_hd__dfxtp_4
XFILLER_0_97 VGND VPWR VPWR VGND sky130_ef_sc_hd__decap_12
XFILLER_2_150 VPWR VGND VPWR VGND sky130_fd_sc_hd__decap_8
X_0757_ VGND VPWR VGND VPWR _0789_/B _0758_/B _0789_/A sky130_fd_sc_hd__or2b_1
X_0826_ VPWR VGND VPWR VGND _0826_/B _0849_/B _0826_/A _0827_/B sky130_fd_sc_hd__or3_1
XFILLER_0_109 VPWR VGND VPWR VGND sky130_fd_sc_hd__decap_3
X_0688_ VPWR VGND VGND VPWR _0688_/A _0689_/B _0688_/B sky130_fd_sc_hd__nand2_1
XFILLER_18_93 VPWR VGND VPWR VGND sky130_fd_sc_hd__decap_3
X_0611_ VGND VPWR VPWR VGND _0667_/A _0612_/A _0611_/B sky130_fd_sc_hd__xor2_1
X_0542_ VPWR VGND VPWR VGND _0560_/A _0542_/A sky130_fd_sc_hd__inv_2
X_0809_ VPWR VGND VGND VPWR _0811_/A _0810_/B _0810_/A sky130_fd_sc_hd__or2_1
XFILLER_22_3 VPWR VGND VPWR VGND sky130_fd_sc_hd__decap_6
Xfanout3 VPWR VGND _0860_/A reset VPWR VGND sky130_fd_sc_hd__buf_2
X_1025_ VPWR VGND VGND VPWR _1097_/Q _1026_/B Y[14] sky130_fd_sc_hd__nand2_1
XFILLER_14_29 VPWR VGND VPWR VGND sky130_fd_sc_hd__decap_8
XFILLER_29_157 VPWR VGND VPWR VGND sky130_fd_sc_hd__decap_8
XFILLER_29_113 VGND VPWR VPWR VGND sky130_fd_sc_hd__decap_4
X_1008_ VPWR VGND VPWR VGND _0998_/B _1014_/B _0998_/A _1105_/Q sky130_fd_sc_hd__a21boi_1
XFILLER_25_160 VPWR VGND VPWR VGND sky130_fd_sc_hd__decap_8
XFILLER_15_50 VPWR VGND VPWR VGND sky130_fd_sc_hd__decap_6
XFILLER_31_141 VGND VPWR VPWR VGND sky130_ef_sc_hd__decap_12
XFILLER_23_108 VGND VPWR VPWR VGND sky130_fd_sc_hd__decap_4
XFILLER_22_185 VGND VPWR VPWR VGND sky130_fd_sc_hd__decap_4
X_0790_ VPWR VGND VGND VPWR _0791_/B _0795_/B _0791_/A sky130_fd_sc_hd__nand2_1
XFILLER_9_145 VGND VPWR VPWR VGND sky130_ef_sc_hd__decap_12
X_0988_ VPWR VGND VGND VPWR _1004_/B _0989_/B _0989_/A sky130_fd_sc_hd__or2_1
XFILLER_3_97 VGND VPWR VPWR VGND sky130_ef_sc_hd__decap_12
XPHY_EDGE_ROW_25_Left_57 VPWR VGND VPWR VGND sky130_fd_sc_hd__decap_3
X_0773_ VGND VPWR VPWR VGND _0773_/X _0771_/A _0769_/X _0829_/B _0804_/B sky130_fd_sc_hd__o2bb2a_1
XFILLER_19_9 VPWR VGND VPWR VGND sky130_fd_sc_hd__decap_8
Xclkbuf_1_0__f_g_fast.genblk1.g_f2.g_cg.u_cg_p.gclk VGND VPWR clkbuf_0_g_fast.genblk1.g_f2.g_cg.u_cg_p.gclk/X
+ _1102_/CLK VPWR VGND sky130_fd_sc_hd__clkbuf_4
X_0911_ VPWR VGND VGND VPWR _0911_/A _0912_/B _0911_/B sky130_fd_sc_hd__nand2_1
X_0842_ _1099_/D _0633_/A _0842_/B VGND VPWR VPWR VGND sky130_fd_sc_hd__and2b_1
X_1041_ VGND VPWR VGND VPWR _1043_/A _1107_/Q _1026_/A _1026_/B sky130_fd_sc_hd__a21bo_1
X_1110_ Y[0] _1129_/CLK _1110_/D VPWR VGND VPWR VGND sky130_fd_sc_hd__dfxtp_2
X_0756_ VPWR VGND VGND VPWR _0756_/A _0789_/B _0756_/B sky130_fd_sc_hd__nand2_1
X_0825_ VPWR VGND VGND VPWR _0804_/A _0826_/B _0849_/B _0825_/X sky130_fd_sc_hd__o21a_1
X_0687_ VPWR VGND VGND VPWR _0687_/A _0688_/B _0687_/B sky130_fd_sc_hd__nand2_1
XFILLER_18_61 VPWR VGND VPWR VGND sky130_fd_sc_hd__decap_6
XPHY_EDGE_ROW_28_Left_60 VPWR VGND VPWR VGND sky130_fd_sc_hd__decap_3
X_0808_ VPWR VGND VPWR VGND _0810_/A _0808_/A sky130_fd_sc_hd__inv_2
X_1024_ VPWR VGND VGND VPWR _1026_/A _1097_/Q Y[14] sky130_fd_sc_hd__or2_1
X_0610_ VPWR VGND VGND VPWR _0668_/A _0611_/B _0610_/B sky130_fd_sc_hd__nand2_1
X_0541_ VPWR VGND VGND VPWR B[2] _0542_/A A[1] sky130_fd_sc_hd__nand2_1
Xfanout4 VPWR VGND _0659_/B B[1] VPWR VGND sky130_fd_sc_hd__buf_2
XPHY_EDGE_ROW_12_Left_44 VPWR VGND VPWR VGND sky130_fd_sc_hd__decap_3
X_0739_ VPWR VGND VPWR VGND A[5] A[6] B[3] _0778_/A B[4] sky130_fd_sc_hd__a22o_1
XFILLER_26_106 VPWR VGND VPWR VGND sky130_fd_sc_hd__decap_8
X_1007_ VPWR VGND VPWR VGND _1006_/Y _1005_/X _0860_/A _1122_/D sky130_fd_sc_hd__a21oi_1
XFILLER_31_153 VGND VPWR VPWR VGND sky130_ef_sc_hd__decap_12
XFILLER_9_157 VPWR VGND VPWR VGND sky130_fd_sc_hd__decap_6
X_0987_ VGND VPWR VPWR VGND _1104_/Q _0989_/A _0987_/B sky130_fd_sc_hd__xor2_1
XPHY_EDGE_ROW_0_Left_32 VPWR VGND VPWR VGND sky130_fd_sc_hd__decap_3
XPHY_EDGE_ROW_25_Right_25 VPWR VGND VPWR VGND sky130_fd_sc_hd__decap_3
X_0772_ VPWR VGND VPWR VGND _0829_/B B[5] sky130_fd_sc_hd__inv_2
X_0841_ VGND VPWR VGND VPWR _1097_/D _0826_/A _0826_/B A[7] B[7] sky130_fd_sc_hd__o211a_1
XPHY_EDGE_ROW_16_Right_16 VPWR VGND VPWR VGND sky130_fd_sc_hd__decap_3
X_0910_ VPWR VGND VGND VPWR _0927_/B _0911_/B _0911_/A sky130_fd_sc_hd__or2_1
XFILLER_23_84 VGND VPWR VPWR VGND sky130_ef_sc_hd__decap_12
X_1040_ VPWR VGND _1043_/B _1053_/A _1040_/A VPWR VGND sky130_fd_sc_hd__and2_1
XFILLER_2_141 VGND VPWR VPWR VGND sky130_fd_sc_hd__decap_4
XFILLER_28_29 VPWR VGND VPWR VGND sky130_fd_sc_hd__decap_6
X_0755_ VPWR VGND VPWR VGND _0756_/A _0789_/A _0756_/B _0758_/A sky130_fd_sc_hd__a21o_1
X_0824_ VPWR VGND VGND VPWR B[7] _0849_/A A[5] sky130_fd_sc_hd__nand2_1
XFILLER_9_64 VGND VPWR VPWR VGND sky130_ef_sc_hd__decap_12
X_0686_ VPWR VGND VGND VPWR _0688_/A _0687_/B _0687_/A sky130_fd_sc_hd__or2_1
X_1023_ VPWR VGND VPWR VGND _1011_/B _1029_/B _1011_/A _1106_/Q sky130_fd_sc_hd__a21boi_1
X_0540_ VPWR VGND VPWR VGND _0551_/B _0540_/A sky130_fd_sc_hd__inv_2
X_0807_ VGND VPWR _0807_/B _0808_/A _0822_/A VPWR VGND sky130_fd_sc_hd__xnor2_1
X_0738_ VPWR VGND VPWR VGND _0804_/B _0799_/C _0769_/C _0826_/B _0740_/A sky130_fd_sc_hd__or4_1
X_0669_ VPWR VGND VGND VPWR _0678_/B _0670_/B _0670_/A sky130_fd_sc_hd__or2_1
Xfanout5 VPWR VGND _0853_/A B[0] VPWR VGND sky130_fd_sc_hd__buf_2
XPHY_EDGE_ROW_2_Right_2 VPWR VGND VPWR VGND sky130_fd_sc_hd__decap_3
XFILLER_20_85 VPWR VGND VPWR VGND sky130_fd_sc_hd__decap_3
X_1006_ VPWR VGND VGND VPWR _1032_/A _1006_/Y _1031_/A sky130_fd_sc_hd__nand2_1
XFILLER_17_107 VGND VPWR VPWR VGND sky130_fd_sc_hd__decap_4
XFILLER_31_165 VPWR VGND VPWR VGND sky130_fd_sc_hd__decap_3
XFILLER_16_184 VPWR VGND VPWR VGND sky130_fd_sc_hd__decap_6
Xdelaybuf_0_clk VGND VPWR delaybuf_0_clk/A delaybuf_1_clk/A VPWR VGND sky130_fd_sc_hd__clkbuf_4
XFILLER_13_121 VPWR VGND VPWR VGND sky130_fd_sc_hd__decap_6
XFILLER_9_125 VGND VPWR VPWR VGND sky130_fd_sc_hd__decap_4
XFILLER_3_77 VGND VPWR VPWR VGND sky130_ef_sc_hd__decap_12
X_0986_ VPWR VGND VGND VPWR _0986_/A _0987_/B _0986_/B sky130_fd_sc_hd__nand2_1
X_0840_ VGND VPWR VPWR VGND _0840_/A _1096_/D _0840_/B sky130_fd_sc_hd__xor2_1
X_0771_ VGND VPWR _0803_/A A[5] _0771_/A B[5] VPWR VGND sky130_fd_sc_hd__and3_1
X_0969_ VGND VPWR _1119_/D _0982_/B _0969_/A _0979_/A VPWR VGND sky130_fd_sc_hd__and3_1
XFILLER_3_109 VPWR VGND VPWR VGND sky130_fd_sc_hd__decap_3
XFILLER_23_96 VGND VPWR VPWR VGND sky130_ef_sc_hd__decap_12
X_0754_ VPWR VGND VPWR VGND _0756_/B _0754_/A sky130_fd_sc_hd__inv_2
X_0823_ VPWR VGND VGND VPWR _0823_/A _0835_/A _0823_/B sky130_fd_sc_hd__nand2_1
X_0685_ VGND VPWR VPWR VGND _0685_/A _0687_/A _0685_/B sky130_fd_sc_hd__xor2_1
XFILLER_18_85 VPWR VGND VPWR VGND sky130_fd_sc_hd__decap_8
X_1099_ _1099_/Q _1102_/CLK _1099_/D VPWR VGND VPWR VGND sky130_fd_sc_hd__dfxtp_1
X_1022_ VPWR VGND VPWR VGND _1021_/Y _1020_/X _0860_/A _1123_/D sky130_fd_sc_hd__a21oi_1
X_0806_ VPWR VGND VGND VPWR _0823_/A _0807_/B _0806_/B sky130_fd_sc_hd__nand2_1
X_0737_ VPWR VGND VGND VPWR A[4] _0741_/A B[5] sky130_fd_sc_hd__nand2_1
X_0668_ VPWR VGND _0670_/A _0668_/B _0668_/A VPWR VGND sky130_fd_sc_hd__and2_1
Xfanout6 VPWR VGND _0853_/B A[0] VPWR VGND sky130_fd_sc_hd__buf_2
X_0599_ VPWR VGND VPWR VGND _0689_/A _0599_/A sky130_fd_sc_hd__inv_2
X_1005_ VPWR VGND VGND VPWR _1005_/X _1031_/A _1032_/A sky130_fd_sc_hd__or2_1
XFILLER_6_55 VGND VPWR VPWR VGND sky130_ef_sc_hd__decap_12
XFILLER_6_77 VPWR VGND VPWR VGND sky130_fd_sc_hd__decap_6
XFILLER_31_85 VGND VPWR VPWR VGND sky130_ef_sc_hd__decap_12
XFILLER_31_41 VGND VPWR VPWR VGND sky130_ef_sc_hd__decap_12
XFILLER_15_20 VGND VPWR VPWR VGND sky130_ef_sc_hd__decap_12
XFILLER_31_177 VGND VPWR VPWR VGND sky130_ef_sc_hd__decap_12
.ends
